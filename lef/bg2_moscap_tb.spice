** sch_path: /home/lenny/projects/test/layout/bg2_moscap_tb.sch
**.subckt bg2_moscap_tb
V1 VDDA 0 1.8
V4 net1 0 0
x1 VDDA net1 bg2_moscap
**** begin user architecture code

.param strict_subcts=0
.include bg2_moscap.spice
.lib /usr/local/share/pdk/sky130A/libs.tech/ngspice/sky130.lib.spice tt
.control
dc V1 0.5 0.9 0.05
print all
save all
write bg2_moscap_data.raw
.endc

**** end user architecture code
**.ends
.end
