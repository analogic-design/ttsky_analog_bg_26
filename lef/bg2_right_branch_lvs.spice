** sch_path: /home/lenny/projects/test/layout/bg2_right_branch_lvs.sch
**.subckt bg2_right_branch_lvs VREF VSSA
*.ipin VSSA
*.ipin VREF
XQ9 VSSA VSSA v_e sky130_fd_pr__pnp_05v5_W3p40L3p40 m=1 mult=1
XQ10 VSSA VSSA v_e sky130_fd_pr__pnp_05v5_W3p40L3p40 m=1 mult=1
XQ11 VSSA VSSA v_e sky130_fd_pr__pnp_05v5_W3p40L3p40 m=1 mult=1
XQ12 VSSA VSSA v_e sky130_fd_pr__pnp_05v5_W3p40L3p40 m=1 mult=1
XQ13 VSSA VSSA v_e sky130_fd_pr__pnp_05v5_W3p40L3p40 m=1 mult=1
XQ14 VSSA VSSA v_e sky130_fd_pr__pnp_05v5_W3p40L3p40 m=1 mult=1
XQ15 VSSA VSSA v_e sky130_fd_pr__pnp_05v5_W3p40L3p40 m=1 mult=1
XQ16 VSSA VSSA v_e sky130_fd_pr__pnp_05v5_W3p40L3p40 m=1 mult=1
XR1 net1 VREF VSSA sky130_fd_pr__res_high_po_0p35 L=5 mult=1
XR2 net2 net1 VSSA sky130_fd_pr__res_high_po_0p35 L=5 mult=1
XR3 net3 net2 VSSA sky130_fd_pr__res_high_po_0p35 L=5 mult=1
XR4 net4 net3 VSSA sky130_fd_pr__res_high_po_0p35 L=5 mult=1
XR5 net5 net4 VSSA sky130_fd_pr__res_high_po_0p35 L=5 mult=1
XR6 net6 net5 VSSA sky130_fd_pr__res_high_po_0p35 L=5 mult=1
XR7 net7 net6 VSSA sky130_fd_pr__res_high_po_0p35 L=5 mult=1
XR8 net8 net7 VSSA sky130_fd_pr__res_high_po_0p35 L=5 mult=1
XR9 net9 net8 VSSA sky130_fd_pr__res_high_po_0p35 L=5 mult=1
XR10 net10 net9 VSSA sky130_fd_pr__res_high_po_0p35 L=5 mult=1
XR11 net11 net10 VSSA sky130_fd_pr__res_high_po_0p35 L=5 mult=1
XR12 net12 net11 VSSA sky130_fd_pr__res_high_po_0p35 L=5 mult=1
XR13 net13 net12 VSSA sky130_fd_pr__res_high_po_0p35 L=5 mult=1
XR14 net14 net13 VSSA sky130_fd_pr__res_high_po_0p35 L=5 mult=1
XR15 net15 net14 VSSA sky130_fd_pr__res_high_po_0p35 L=5 mult=1
XR16 net16 net15 VSSA sky130_fd_pr__res_high_po_0p35 L=5 mult=1
XR17 net17 net16 VSSA sky130_fd_pr__res_high_po_0p35 L=5 mult=1
XR18 net18 net17 VSSA sky130_fd_pr__res_high_po_0p35 L=5 mult=1
XR19 net19 net18 VSSA sky130_fd_pr__res_high_po_0p35 L=5 mult=1
XR20 net20 net19 VSSA sky130_fd_pr__res_high_po_0p35 L=5 mult=1
XR21 net21 net20 VSSA sky130_fd_pr__res_high_po_0p35 L=5 mult=1
XR22 net22 net21 VSSA sky130_fd_pr__res_high_po_0p35 L=5 mult=1
XR23 net23 net22 VSSA sky130_fd_pr__res_high_po_0p35 L=5 mult=1
XR24 net24 net23 VSSA sky130_fd_pr__res_high_po_0p35 L=5 mult=1
XR25 net25 net24 VSSA sky130_fd_pr__res_high_po_0p35 L=5 mult=1
XR26 net26 net25 VSSA sky130_fd_pr__res_high_po_0p35 L=5 mult=1
XR27 net27 net26 VSSA sky130_fd_pr__res_high_po_0p35 L=5 mult=1
XR28 net28 net27 VSSA sky130_fd_pr__res_high_po_0p35 L=5 mult=1
XR29 net29 net28 VSSA sky130_fd_pr__res_high_po_0p35 L=5 mult=1
XR30 net30 net29 VSSA sky130_fd_pr__res_high_po_0p35 L=5 mult=1
XR31 net31 net30 VSSA sky130_fd_pr__res_high_po_0p35 L=5 mult=1
XR32 net32 net31 VSSA sky130_fd_pr__res_high_po_0p35 L=5 mult=1
XR33 net33 net32 VSSA sky130_fd_pr__res_high_po_0p35 L=5 mult=1
XR34 net34 net33 VSSA sky130_fd_pr__res_high_po_0p35 L=5 mult=1
XR35 net35 net34 VSSA sky130_fd_pr__res_high_po_0p35 L=5 mult=1
XR36 net36 net35 VSSA sky130_fd_pr__res_high_po_0p35 L=5 mult=1
XR37 net37 net36 VSSA sky130_fd_pr__res_high_po_0p35 L=5 mult=1
XR38 net38 net37 VSSA sky130_fd_pr__res_high_po_0p35 L=5 mult=1
XR39 net39 net38 VSSA sky130_fd_pr__res_high_po_0p35 L=5 mult=1
XR40 net40 net39 VSSA sky130_fd_pr__res_high_po_0p35 L=5 mult=1
XR41 net41 net40 VSSA sky130_fd_pr__res_high_po_0p35 L=5 mult=1
XR42 net42 net41 VSSA sky130_fd_pr__res_high_po_0p35 L=5 mult=1
XR43 net43 net42 VSSA sky130_fd_pr__res_high_po_0p35 L=5 mult=1
XR44 net44 net43 VSSA sky130_fd_pr__res_high_po_0p35 L=5 mult=1
XR45 net45 net44 VSSA sky130_fd_pr__res_high_po_0p35 L=5 mult=1
XR46 net46 net45 VSSA sky130_fd_pr__res_high_po_0p35 L=5 mult=1
XR47 net47 net46 VSSA sky130_fd_pr__res_high_po_0p35 L=5 mult=1
XR48 net48 net47 VSSA sky130_fd_pr__res_high_po_0p35 L=5 mult=1
XR49 net49 net48 VSSA sky130_fd_pr__res_high_po_0p35 L=5 mult=1
XR50 net50 net49 VSSA sky130_fd_pr__res_high_po_0p35 L=5 mult=1
XR51 net51 net50 VSSA sky130_fd_pr__res_high_po_0p35 L=5 mult=1
XR52 net52 net51 VSSA sky130_fd_pr__res_high_po_0p35 L=5 mult=1
XR53 net53 net52 VSSA sky130_fd_pr__res_high_po_0p35 L=5 mult=1
XR54 net54 net53 VSSA sky130_fd_pr__res_high_po_0p35 L=5 mult=1
XR55 net55 net54 VSSA sky130_fd_pr__res_high_po_0p35 L=5 mult=1
XR56 net56 net55 VSSA sky130_fd_pr__res_high_po_0p35 L=5 mult=1
XR57 net57 net56 VSSA sky130_fd_pr__res_high_po_0p35 L=5 mult=1
XR58 net58 net57 VSSA sky130_fd_pr__res_high_po_0p35 L=5 mult=1
XR59 net59 net58 VSSA sky130_fd_pr__res_high_po_0p35 L=5 mult=1
XR60 net60 net59 VSSA sky130_fd_pr__res_high_po_0p35 L=5 mult=1
XR61 net61 net60 VSSA sky130_fd_pr__res_high_po_0p35 L=5 mult=1
XR62 net62 net61 VSSA sky130_fd_pr__res_high_po_0p35 L=5 mult=1
XR63 net63 net62 VSSA sky130_fd_pr__res_high_po_0p35 L=5 mult=1
XR64 net64 net63 VSSA sky130_fd_pr__res_high_po_0p35 L=5 mult=1
XR65 net65 net64 VSSA sky130_fd_pr__res_high_po_0p35 L=5 mult=1
XR66 net66 net65 VSSA sky130_fd_pr__res_high_po_0p35 L=5 mult=1
XR67 net67 net66 VSSA sky130_fd_pr__res_high_po_0p35 L=5 mult=1
XR68 net68 net67 VSSA sky130_fd_pr__res_high_po_0p35 L=5 mult=1
XR69 net69 net68 VSSA sky130_fd_pr__res_high_po_0p35 L=5 mult=1
XR70 net70 net69 VSSA sky130_fd_pr__res_high_po_0p35 L=5 mult=1
XR71 net71 net70 VSSA sky130_fd_pr__res_high_po_0p35 L=5 mult=1
XR72 net72 net71 VSSA sky130_fd_pr__res_high_po_0p35 L=5 mult=1
XR73 net73 net72 VSSA sky130_fd_pr__res_high_po_0p35 L=5 mult=1
XR74 net74 net73 VSSA sky130_fd_pr__res_high_po_0p35 L=5 mult=1
XR75 net75 net74 VSSA sky130_fd_pr__res_high_po_0p35 L=5 mult=1
XR76 net76 net75 VSSA sky130_fd_pr__res_high_po_0p35 L=5 mult=1
XR77 net77 net76 VSSA sky130_fd_pr__res_high_po_0p35 L=5 mult=1
XR78 net78 net77 VSSA sky130_fd_pr__res_high_po_0p35 L=5 mult=1
XR79 net79 net78 VSSA sky130_fd_pr__res_high_po_0p35 L=5 mult=1
XR80 net80 net79 VSSA sky130_fd_pr__res_high_po_0p35 L=5 mult=1
XR81 net81 net80 VSSA sky130_fd_pr__res_high_po_0p35 L=5 mult=1
XR82 net82 net81 VSSA sky130_fd_pr__res_high_po_0p35 L=5 mult=1
XR83 net83 net82 VSSA sky130_fd_pr__res_high_po_0p35 L=5 mult=1
XR84 net84 net83 VSSA sky130_fd_pr__res_high_po_0p35 L=5 mult=1
XR85 net85 net84 VSSA sky130_fd_pr__res_high_po_0p35 L=5 mult=1
XR86 net86 net85 VSSA sky130_fd_pr__res_high_po_0p35 L=5 mult=1
XR87 net87 net86 VSSA sky130_fd_pr__res_high_po_0p35 L=5 mult=1
XR88 net88 net87 VSSA sky130_fd_pr__res_high_po_0p35 L=5 mult=1
XR89 net89 net88 VSSA sky130_fd_pr__res_high_po_0p35 L=5 mult=1
XR90 net90 net89 VSSA sky130_fd_pr__res_high_po_0p35 L=5 mult=1
XR91 net91 net90 VSSA sky130_fd_pr__res_high_po_0p35 L=5 mult=1
XR92 net92 net91 VSSA sky130_fd_pr__res_high_po_0p35 L=5 mult=1
XR93 net93 net92 VSSA sky130_fd_pr__res_high_po_0p35 L=5 mult=1
XR94 net94 net93 VSSA sky130_fd_pr__res_high_po_0p35 L=5 mult=1
XR95 net95 net94 VSSA sky130_fd_pr__res_high_po_0p35 L=5 mult=1
XR96 net96 net95 VSSA sky130_fd_pr__res_high_po_0p35 L=5 mult=1
XR97 net97 net96 VSSA sky130_fd_pr__res_high_po_0p35 L=5 mult=1
XR98 net98 net97 VSSA sky130_fd_pr__res_high_po_0p35 L=5 mult=1
XR99 net99 net98 VSSA sky130_fd_pr__res_high_po_0p35 L=5 mult=1
XR100 net100 net99 VSSA sky130_fd_pr__res_high_po_0p35 L=5 mult=1
XR101 net101 net100 VSSA sky130_fd_pr__res_high_po_0p35 L=5 mult=1
XR102 net102 net101 VSSA sky130_fd_pr__res_high_po_0p35 L=5 mult=1
XR103 net103 net102 VSSA sky130_fd_pr__res_high_po_0p35 L=5 mult=1
XR104 net104 net103 VSSA sky130_fd_pr__res_high_po_0p35 L=5 mult=1
XR105 net105 net104 VSSA sky130_fd_pr__res_high_po_0p35 L=5 mult=1
XR106 net106 net105 VSSA sky130_fd_pr__res_high_po_0p35 L=5 mult=1
XR107 net107 net106 VSSA sky130_fd_pr__res_high_po_0p35 L=5 mult=1
XR108 net108 net107 VSSA sky130_fd_pr__res_high_po_0p35 L=5 mult=1
XR109 net109 net108 VSSA sky130_fd_pr__res_high_po_0p35 L=5 mult=1
XR110 net110 net109 VSSA sky130_fd_pr__res_high_po_0p35 L=5 mult=1
XR111 net111 net110 VSSA sky130_fd_pr__res_high_po_0p35 L=5 mult=1
XR112 net112 net111 VSSA sky130_fd_pr__res_high_po_0p35 L=5 mult=1
XR113 net113 net112 VSSA sky130_fd_pr__res_high_po_0p35 L=5 mult=1
XR114 net114 net113 VSSA sky130_fd_pr__res_high_po_0p35 L=5 mult=1
XR115 net115 net114 VSSA sky130_fd_pr__res_high_po_0p35 L=5 mult=1
XR116 net116 net115 VSSA sky130_fd_pr__res_high_po_0p35 L=5 mult=1
XR117 v_e net116 VSSA sky130_fd_pr__res_high_po_0p35 L=5 mult=1
**.ends
.end
