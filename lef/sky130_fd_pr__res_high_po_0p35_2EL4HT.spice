* SPICE3 file created from sky130_fd_pr__res_high_po_0p35_2EL4HT.ext - technology: sky130A

.subckt sky130_fd_pr__res_high_po_0p35_2EL4HT VIN VSUBS VOUT
X0 VOUT VIN VSUBS sky130_fd_pr__res_high_po_0p35 l=25
.ends
