** sch_path: /home/lenny/projects/test/layout/bg2_res_array_complete_tb.sch
**.subckt bg2_res_array_complete_tb
V1 vin 0 1
x1 vin vin net1 net3 net2 bg2_res_array_complete
V2 net1 0 0
V3 net2 0 0
V4 net3 0 0
**** begin user architecture code

.param strict_subcts=0
.include bg2_res_array_complete.spice
.lib /usr/local/share/pdk/sky130A/libs.tech/ngspice/sky130.lib.spice tt
.control
dc V1 0 1.8 0.2
print all
save all
write bg2_res_array_complete_data.raw
.endc

**** end user architecture code
**.ends
.end
