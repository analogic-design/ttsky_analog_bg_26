* SPICE3 file created from bg2_decoupling_cap_lvs.ext - technology: sky130A

X0 VDDA vbp1 VDDA VDDA sky130_fd_pr__pfet_01v8_lvt ad=2.9 pd=20.58 as=2.9 ps=20.58 w=10 l=10
X1 VDDA vbp1 VDDA VDDA sky130_fd_pr__pfet_01v8_lvt ad=2.9 pd=20.58 as=2.9 ps=20.58 w=10 l=10
X2 VDDA vbp1 VDDA VDDA sky130_fd_pr__pfet_01v8_lvt ad=2.9 pd=20.58 as=2.9 ps=20.58 w=10 l=10
X3 VDDA vbp1 VDDA VDDA sky130_fd_pr__pfet_01v8_lvt ad=2.9 pd=20.58 as=2.9 ps=20.58 w=10 l=10
X4 VDDA vbp1 VDDA VDDA sky130_fd_pr__pfet_01v8_lvt ad=2.9 pd=20.58 as=2.9 ps=20.58 w=10 l=10
X5 VDDA vbp1 VDDA VDDA sky130_fd_pr__pfet_01v8_lvt ad=2.9 pd=20.58 as=2.9 ps=20.58 w=10 l=10
X6 VDDA vbp1 VDDA VDDA sky130_fd_pr__pfet_01v8_lvt ad=2.9 pd=20.58 as=2.9 ps=20.58 w=10 l=10
X7 VDDA vbp1 VDDA VDDA sky130_fd_pr__pfet_01v8_lvt ad=2.9 pd=20.58 as=2.9 ps=20.58 w=10 l=10
X8 VDDA vbp1 VDDA VDDA sky130_fd_pr__pfet_01v8_lvt ad=2.9 pd=20.58 as=2.9 ps=20.58 w=10 l=10
X9 VDDA vbp1 VDDA VDDA sky130_fd_pr__pfet_01v8_lvt ad=2.9 pd=20.58 as=2.9 ps=20.58 w=10 l=10
