* SPICE3 file created from bg2_top_tt_lvs.ext - technology: sky130A

X0 bg2_opamp_0/vb bg2_opamp_0/vb VPWR VPWR sky130_fd_pr__pfet_01v8_lvt ad=1.16 pd=8.58 as=1.16 ps=8.58 w=4 l=6
X1 VPWR bg2_opamp_0/vb vbp1 VPWR sky130_fd_pr__pfet_01v8_lvt ad=73.08005 pd=523.15002 as=2.32002 ps=17.165 w=4 l=6
X2 vbp1 bg2_opamp_0/vb VPWR VPWR sky130_fd_pr__pfet_01v8_lvt ad=1.16 pd=8.58 as=1.16 ps=8.58 w=4 l=6
X3 bg2_opamp_0/vb V_PLUS bg2_opamp_0/sky130_fd_pr__nfet_01v8_Y4G2KK_0/S VGND sky130_fd_pr__nfet_01v8 ad=1.16 pd=8.58 as=1.16 ps=8.58 w=4 l=6
X4 bg2_opamp_0/sky130_fd_pr__nfet_01v8_Y4G2KK_0/S V_PLUS bg2_opamp_0/vb VGND sky130_fd_pr__nfet_01v8 ad=1.16 pd=8.58 as=1.16 ps=8.58 w=4 l=6
X5 VPWR bg2_opamp_0/vb bg2_opamp_0/vb VPWR sky130_fd_pr__pfet_01v8_lvt ad=1.16 pd=8.58 as=1.16 ps=8.58 w=4 l=6
X6 vbp1 V_MINUS bg2_opamp_0/sky130_fd_pr__nfet_01v8_Y4G2KK_0/S VGND sky130_fd_pr__nfet_01v8 ad=1.16 pd=8.58 as=1.16 ps=8.58 w=4 l=6
X7 bg2_opamp_0/sky130_fd_pr__nfet_01v8_Y4G2KK_0/S V_MINUS vbp1 VGND sky130_fd_pr__nfet_01v8 ad=1.16 pd=8.58 as=1.16 ps=8.58 w=4 l=6
X8 VGND bg2_opamp_0/vb bg2_opamp_0/sky130_fd_pr__nfet_01v8_Y4G2KK_0/S VGND sky130_fd_pr__nfet_01v8 ad=0.145 pd=1.58 as=0.145 ps=1.58 w=0.5 l=10
X9 bg2_opamp_0/sky130_fd_pr__nfet_01v8_Y4G2KK_0/S bg2_opamp_0/vb VGND VGND sky130_fd_pr__nfet_01v8 ad=0.145 pd=1.58 as=0.145 ps=1.58 w=0.5 l=10
X10 VGND VPWR VGND VGND sky130_fd_pr__nfet_01v8 ad=2.9 pd=20.58 as=2.9 ps=20.58 w=10 l=10
X11 VGND VPWR VGND VGND sky130_fd_pr__nfet_01v8 ad=2.9 pd=20.58 as=2.9 ps=20.58 w=10 l=10
X12 VGND VPWR VGND VGND sky130_fd_pr__nfet_01v8 ad=2.9 pd=20.58 as=2.9 ps=20.58 w=10 l=10
X13 VGND VPWR VGND VGND sky130_fd_pr__nfet_01v8 ad=2.9 pd=20.58 as=2.9 ps=20.58 w=10 l=10
X14 VGND VPWR VGND VGND sky130_fd_pr__nfet_01v8 ad=2.9 pd=20.58 as=2.9 ps=20.58 w=10 l=10
X15 VGND VPWR VGND VGND sky130_fd_pr__nfet_01v8 ad=2.9 pd=20.58 as=2.9 ps=20.58 w=10 l=10
X16 VGND VPWR VGND VGND sky130_fd_pr__nfet_01v8 ad=2.9 pd=20.58 as=2.9 ps=20.58 w=10 l=10
X17 VGND VPWR VGND VGND sky130_fd_pr__nfet_01v8 ad=2.9 pd=20.58 as=2.9 ps=20.58 w=10 l=10
X18 VGND VPWR VGND VGND sky130_fd_pr__nfet_01v8 ad=2.9 pd=20.58 as=2.9 ps=20.58 w=10 l=10
X19 VGND VPWR VGND VGND sky130_fd_pr__nfet_01v8 ad=2.9 pd=20.58 as=2.9 ps=20.58 w=10 l=10
X20 VPWR VPWR VPWR VPWR sky130_fd_pr__pfet_01v8_lvt ad=1.16 pd=8.58 as=1.16 ps=8.58 w=4 l=6
X21 V_PLUS vbp1 VPWR VPWR sky130_fd_pr__pfet_01v8_lvt ad=13.88002 pd=30.765 as=0 ps=0 w=4 l=6
X22 VPWR vbp1 V_PLUS VPWR sky130_fd_pr__pfet_01v8_lvt ad=0 pd=0 as=0 ps=0 w=4 l=6
X23 V_MINUS vbp1 VPWR VPWR sky130_fd_pr__pfet_01v8_lvt ad=1.16003 pd=8.585 as=0 ps=0 w=4 l=6
X24 VREF vbp1 VPWR VPWR sky130_fd_pr__pfet_01v8_lvt ad=1.16003 pd=8.585 as=0 ps=0 w=4 l=6
X25 VPWR vbp1 V_MINUS VPWR sky130_fd_pr__pfet_01v8_lvt ad=0 pd=0 as=0 ps=0 w=4 l=6
X26 VPWR vbp1 VREF VPWR sky130_fd_pr__pfet_01v8_lvt ad=0 pd=0 as=0 ps=0 w=4 l=6
X27 VPWR VPWR VPWR VPWR sky130_fd_pr__pfet_01v8_lvt ad=0 pd=0 as=0 ps=0 w=4 l=6
X28 VPWR VPWR VPWR VPWR sky130_fd_pr__pfet_01v8_lvt ad=1.16 pd=8.58 as=1.16 ps=8.58 w=4 l=6
X29 VPWR VPWR VPWR VPWR sky130_fd_pr__pfet_01v8_lvt ad=1.16 pd=8.58 as=1.16 ps=8.58 w=4 l=6
X30 VPWR vbp1 VPWR VPWR sky130_fd_pr__pfet_01v8_lvt ad=2.9 pd=20.58 as=2.9 ps=20.58 w=10 l=10
X31 VPWR vbp1 VPWR VPWR sky130_fd_pr__pfet_01v8_lvt ad=2.9 pd=20.58 as=2.9 ps=20.58 w=10 l=10
X32 VPWR vbp1 VPWR VPWR sky130_fd_pr__pfet_01v8_lvt ad=2.9 pd=20.58 as=2.9 ps=20.58 w=10 l=10
X33 VPWR vbp1 VPWR VPWR sky130_fd_pr__pfet_01v8_lvt ad=2.9 pd=20.58 as=2.9 ps=20.58 w=10 l=10
X34 VPWR vbp1 VPWR VPWR sky130_fd_pr__pfet_01v8_lvt ad=2.9 pd=20.58 as=2.9 ps=20.58 w=10 l=10
X35 VPWR vbp1 VPWR VPWR sky130_fd_pr__pfet_01v8_lvt ad=2.9 pd=20.58 as=2.9 ps=20.58 w=10 l=10
X36 VPWR vbp1 VPWR VPWR sky130_fd_pr__pfet_01v8_lvt ad=2.9 pd=20.58 as=2.9 ps=20.58 w=10 l=10
X37 VPWR vbp1 VPWR VPWR sky130_fd_pr__pfet_01v8_lvt ad=2.9 pd=20.58 as=2.9 ps=20.58 w=10 l=10
X38 VPWR vbp1 VPWR VPWR sky130_fd_pr__pfet_01v8_lvt ad=2.9 pd=20.58 as=2.9 ps=20.58 w=10 l=10
X39 VPWR vbp1 VPWR VPWR sky130_fd_pr__pfet_01v8_lvt ad=2.9 pd=20.58 as=2.9 ps=20.58 w=10 l=10
X40 bg2_startup_0/sky130_fd_pr__nfet_01v8_BH8H9B_0/G vbp1 VPWR VPWR sky130_fd_pr__pfet_01v8_lvt ad=1.16 pd=8.58 as=1.16 ps=8.58 w=4 l=6
X41 VGND bg2_startup_0/sky130_fd_pr__nfet_01v8_BH8H9B_0/G bg2_startup_0/sky130_fd_pr__nfet_01v8_BH8H9B_0/G VGND sky130_fd_pr__nfet_01v8 ad=0.29 pd=2.58 as=0.29 ps=2.58 w=1 l=100
X42 VPWR vbp1 bg2_startup_0/sky130_fd_pr__nfet_01v8_BH8H9B_0/G VPWR sky130_fd_pr__pfet_01v8_lvt ad=0 pd=0 as=1.16003 ps=8.585 w=4 l=6
X43 V_PLUS bg2_startup_0/sky130_fd_pr__nfet_01v8_BH8H9B_0/G vbp1 VPWR sky130_fd_pr__pfet_01v8_lvt ad=1.16 pd=8.58 as=1.16 ps=8.58 w=4 l=3
X44 bg2_res_array_complete_0/sky130_fd_pr__res_high_po_0p35_WZRS6E_0/R1_13_5 bg2_res_array_complete_0/sky130_fd_pr__res_high_po_0p35_WZRS6E_0/R2_13_5 VGND sky130_fd_pr__res_high_po_0p35 l=5
X45 bg2_res_array_complete_0/sky130_fd_pr__res_high_po_0p35_WZRS6E_0/R2_24_5 bg2_res_array_complete_0/sky130_fd_pr__res_high_po_0p35_WZRS6E_0/R2_24_4 VGND sky130_fd_pr__res_high_po_0p35 l=5
X46 bg2_res_array_complete_0/sky130_fd_pr__res_high_po_0p35_WZRS6E_0/R2_18_4 bg2_res_array_complete_0/sky130_fd_pr__res_high_po_0p35_WZRS6E_0/R2_18_3 VGND sky130_fd_pr__res_high_po_0p35 l=5
X47 bg2_res_array_complete_0/sky130_fd_pr__res_high_po_0p35_WZRS6E_0/R2_14_2 bg2_res_array_complete_0/sky130_fd_pr__res_high_po_0p35_WZRS6E_0/R2_14_1 VGND sky130_fd_pr__res_high_po_0p35 l=5
X48 bg2_res_array_complete_0/sky130_fd_pr__res_high_po_0p35_WZRS6E_0/R2_6_3 bg2_res_array_complete_0/sky130_fd_pr__res_high_po_0p35_WZRS6E_0/R2_6_2 VGND sky130_fd_pr__res_high_po_0p35 l=5
X49 VGND VGND VGND sky130_fd_pr__res_high_po_0p35 l=5
X50 VGND VGND VGND sky130_fd_pr__res_high_po_0p35 l=5
X51 bg2_res_array_complete_0/sky130_fd_pr__res_high_po_0p35_WZRS6E_0/R2_7_5 bg2_res_array_complete_0/sky130_fd_pr__res_high_po_0p35_WZRS6E_0/R2_7_4 VGND sky130_fd_pr__res_high_po_0p35 l=5
X52 bg2_res_array_complete_0/sky130_fd_pr__res_high_po_0p35_WZRS6E_0/R2_6_4 bg2_res_array_complete_0/sky130_fd_pr__res_high_po_0p35_WZRS6E_0/R2_6_3 VGND sky130_fd_pr__res_high_po_0p35 l=5
X53 bg2_res_array_complete_0/sky130_fd_pr__res_high_po_0p35_WZRS6E_0/R2_2_3 VREF VGND sky130_fd_pr__res_high_po_0p35 l=5
X54 VGND VGND VGND sky130_fd_pr__res_high_po_0p35 l=5
X55 VGND VGND VGND sky130_fd_pr__res_high_po_0p35 l=5
X56 VGND VGND VGND sky130_fd_pr__res_high_po_0p35 l=5
X57 VGND VGND VGND sky130_fd_pr__res_high_po_0p35 l=5
X58 bg2_res_array_complete_0/sky130_fd_pr__res_high_po_0p35_WZRS6E_0/R1_21_5 bg2_res_array_complete_0/sky130_fd_pr__res_high_po_0p35_WZRS6E_0/R2_21_5 VGND sky130_fd_pr__res_high_po_0p35 l=5
X59 VGND VGND VGND sky130_fd_pr__res_high_po_0p35 l=5
X60 bg2_res_array_complete_0/sky130_fd_pr__res_high_po_0p35_WZRS6E_0/R1_5_1 bg2_res_array_complete_0/sky130_fd_pr__res_high_po_0p35_WZRS6E_0/R2_4_1 VGND sky130_fd_pr__res_high_po_0p35 l=5
X61 bg2_res_array_complete_0/sky130_fd_pr__res_high_po_0p35_WZRS6E_0/R2_26_3 bg2_res_array_complete_0/sky130_fd_pr__res_high_po_0p35_WZRS6E_0/R2_26_2 VGND sky130_fd_pr__res_high_po_0p35 l=5
X62 VGND VGND VGND sky130_fd_pr__res_high_po_0p35 l=5
X63 VGND VGND VGND sky130_fd_pr__res_high_po_0p35 l=5
X64 VGND VGND VGND sky130_fd_pr__res_high_po_0p35 l=5
X65 VGND VGND VGND sky130_fd_pr__res_high_po_0p35 l=5
X66 VGND VGND VGND sky130_fd_pr__res_high_po_0p35 l=5
X67 bg2_res_array_complete_0/sky130_fd_pr__res_high_po_0p35_WZRS6E_0/R1_3_5 bg2_res_array_complete_0/sky130_fd_pr__res_high_po_0p35_WZRS6E_0/R2_3_5 VGND sky130_fd_pr__res_high_po_0p35 l=5
X68 bg2_res_array_complete_0/sky130_fd_pr__res_high_po_0p35_WZRS6E_0/R2_9_5 bg2_res_array_complete_0/sky130_fd_pr__res_high_po_0p35_WZRS6E_0/R2_9_4 VGND sky130_fd_pr__res_high_po_0p35 l=5
X69 bg2_res_array_complete_0/sky130_fd_pr__res_high_po_0p35_WZRS6E_0/R2_23_4 bg2_res_array_complete_0/sky130_fd_pr__res_high_po_0p35_WZRS6E_0/R2_23_3 VGND sky130_fd_pr__res_high_po_0p35 l=5
X70 bg2_res_array_complete_0/sky130_fd_pr__res_high_po_0p35_WZRS6E_0/R2_16_4 bg2_res_array_complete_0/sky130_fd_pr__res_high_po_0p35_WZRS6E_0/R2_16_3 VGND sky130_fd_pr__res_high_po_0p35 l=5
X71 bg2_res_array_complete_0/sky130_fd_pr__res_high_po_0p35_WZRS6E_0/R2_22_5 bg2_res_array_complete_0/sky130_fd_pr__res_high_po_0p35_WZRS6E_0/R2_22_4 VGND sky130_fd_pr__res_high_po_0p35 l=5
X72 bg2_res_array_complete_0/sky130_fd_pr__res_high_po_0p35_WZRS6E_0/R1_11_1 bg2_bjt_array_0/VE_MINUS VGND sky130_fd_pr__res_high_po_0p35 l=5
X73 bg2_res_array_complete_0/sky130_fd_pr__res_high_po_0p35_WZRS6E_0/R1_15_5 bg2_res_array_complete_0/sky130_fd_pr__res_high_po_0p35_WZRS6E_0/R2_15_5 VGND sky130_fd_pr__res_high_po_0p35 l=5
X74 bg2_res_array_complete_0/sky130_fd_pr__res_high_po_0p35_WZRS6E_0/R2_3_3 bg2_res_array_complete_0/sky130_fd_pr__res_high_po_0p35_WZRS6E_0/R2_4_2 VGND sky130_fd_pr__res_high_po_0p35 l=5
X75 VGND VGND VGND sky130_fd_pr__res_high_po_0p35 l=5
X76 VGND VGND VGND sky130_fd_pr__res_high_po_0p35 l=5
X77 bg2_res_array_complete_0/sky130_fd_pr__res_high_po_0p35_WZRS6E_0/R2_16_3 bg2_res_array_complete_0/sky130_fd_pr__res_high_po_0p35_WZRS6E_0/R2_16_2 VGND sky130_fd_pr__res_high_po_0p35 l=5
X78 bg2_res_array_complete_0/sky130_fd_pr__res_high_po_0p35_WZRS6E_0/R1_13_5 bg2_res_array_complete_0/sky130_fd_pr__res_high_po_0p35_WZRS6E_0/R2_12_5 VGND sky130_fd_pr__res_high_po_0p35 l=5
X79 bg2_res_array_complete_0/sky130_fd_pr__res_high_po_0p35_WZRS6E_0/R2_8_4 bg2_res_array_complete_0/sky130_fd_pr__res_high_po_0p35_WZRS6E_0/R2_8_3 VGND sky130_fd_pr__res_high_po_0p35 l=5
X80 bg2_res_array_complete_0/sky130_fd_pr__res_high_po_0p35_WZRS6E_0/R2_21_2 bg2_res_array_complete_0/sky130_fd_pr__res_high_po_0p35_WZRS6E_0/R2_22_1 VGND sky130_fd_pr__res_high_po_0p35 l=5
X81 bg2_res_array_complete_0/sky130_fd_pr__res_high_po_0p35_WZRS6E_0/R2_25_5 bg2_res_array_complete_0/sky130_fd_pr__res_high_po_0p35_WZRS6E_0/R2_25_4 VGND sky130_fd_pr__res_high_po_0p35 l=5
X82 VGND VGND VGND sky130_fd_pr__res_high_po_0p35 l=5
X83 VGND VGND VGND sky130_fd_pr__res_high_po_0p35 l=5
X84 VGND VGND VGND sky130_fd_pr__res_high_po_0p35 l=5
X85 VGND VGND VGND sky130_fd_pr__res_high_po_0p35 l=5
X86 VGND VGND VGND sky130_fd_pr__res_high_po_0p35 l=5
X87 bg2_res_array_complete_0/sky130_fd_pr__res_high_po_0p35_WZRS6E_0/R2_13_4 bg2_res_array_complete_0/sky130_fd_pr__res_high_po_0p35_WZRS6E_0/R2_13_3 VGND sky130_fd_pr__res_high_po_0p35 l=5
X88 bg2_res_array_complete_0/sky130_fd_pr__res_high_po_0p35_WZRS6E_0/R2_18_2 bg2_res_array_complete_0/sky130_fd_pr__res_high_po_0p35_WZRS6E_0/R2_18_1 VGND sky130_fd_pr__res_high_po_0p35 l=5
X89 bg2_res_array_complete_0/sky130_fd_pr__res_high_po_0p35_WZRS6E_0/R1_27_5 bg2_res_array_complete_0/sky130_fd_pr__res_high_po_0p35_WZRS6E_0/R2_26_5 VGND sky130_fd_pr__res_high_po_0p35 l=5
X90 VGND VGND VGND sky130_fd_pr__res_high_po_0p35 l=5
X91 bg2_res_array_complete_0/sky130_fd_pr__res_high_po_0p35_WZRS6E_0/R2_17_2 bg2_res_array_complete_0/sky130_fd_pr__res_high_po_0p35_WZRS6E_0/R2_18_1 VGND sky130_fd_pr__res_high_po_0p35 l=5
X92 bg2_res_array_complete_0/sky130_fd_pr__res_high_po_0p35_WZRS6E_0/R1_19_5 bg2_res_array_complete_0/sky130_fd_pr__res_high_po_0p35_WZRS6E_0/R2_19_5 VGND sky130_fd_pr__res_high_po_0p35 l=5
X93 VGND VGND VGND sky130_fd_pr__res_high_po_0p35 l=5
X94 bg2_res_array_complete_0/sky130_fd_pr__res_high_po_0p35_WZRS6E_0/R2_11_5 bg2_res_array_complete_0/sky130_fd_pr__res_high_po_0p35_WZRS6E_0/R2_11_4 VGND sky130_fd_pr__res_high_po_0p35 l=5
X95 bg2_res_array_complete_0/sky130_fd_pr__res_high_po_0p35_WZRS6E_0/R1_5_5 bg2_res_array_complete_0/sky130_fd_pr__res_high_po_0p35_WZRS6E_0/R2_5_5 VGND sky130_fd_pr__res_high_po_0p35 l=5
X96 bg2_res_array_complete_0/sky130_fd_pr__res_high_po_0p35_WZRS6E_0/R2_17_5 bg2_res_array_complete_0/sky130_fd_pr__res_high_po_0p35_WZRS6E_0/R2_17_4 VGND sky130_fd_pr__res_high_po_0p35 l=5
X97 bg2_res_array_complete_0/sky130_fd_pr__res_high_po_0p35_WZRS6E_0/R2_22_3 bg2_res_array_complete_0/sky130_fd_pr__res_high_po_0p35_WZRS6E_0/R2_22_2 VGND sky130_fd_pr__res_high_po_0p35 l=5
X98 VGND VGND VGND sky130_fd_pr__res_high_po_0p35 l=5
X99 bg2_res_array_complete_0/sky130_fd_pr__res_high_po_0p35_WZRS6E_0/R2_21_4 bg2_res_array_complete_0/sky130_fd_pr__res_high_po_0p35_WZRS6E_0/R2_21_3 VGND sky130_fd_pr__res_high_po_0p35 l=5
X100 VGND VGND VGND sky130_fd_pr__res_high_po_0p35 l=5
X101 bg2_res_array_complete_0/sky130_fd_pr__res_high_po_0p35_WZRS6E_0/R1_9_1 bg2_res_array_complete_0/sky130_fd_pr__res_high_po_0p35_WZRS6E_0/R2_8_1 VGND sky130_fd_pr__res_high_po_0p35 l=5
X102 bg2_res_array_complete_0/sky130_fd_pr__res_high_po_0p35_WZRS6E_0/R2_7_3 bg2_res_array_complete_0/sky130_fd_pr__res_high_po_0p35_WZRS6E_0/R2_8_2 VGND sky130_fd_pr__res_high_po_0p35 l=5
X103 bg2_res_array_complete_0/sky130_fd_pr__res_high_po_0p35_WZRS6E_0/R2_2_5 bg2_res_array_complete_0/sky130_fd_pr__res_high_po_0p35_WZRS6E_0/R2_2_4 VGND sky130_fd_pr__res_high_po_0p35 l=5
X104 bg2_res_array_complete_0/sky130_fd_pr__res_high_po_0p35_WZRS6E_0/R1_11_5 bg2_res_array_complete_0/sky130_fd_pr__res_high_po_0p35_WZRS6E_0/R2_10_5 VGND sky130_fd_pr__res_high_po_0p35 l=5
X105 bg2_res_array_complete_0/sky130_fd_pr__res_high_po_0p35_WZRS6E_0/R2_20_5 bg2_res_array_complete_0/sky130_fd_pr__res_high_po_0p35_WZRS6E_0/R2_20_4 VGND sky130_fd_pr__res_high_po_0p35 l=5
X106 bg2_res_array_complete_0/sky130_fd_pr__res_high_po_0p35_WZRS6E_0/R2_25_2 bg2_res_array_complete_0/sky130_fd_pr__res_high_po_0p35_WZRS6E_0/R2_26_1 VGND sky130_fd_pr__res_high_po_0p35 l=5
X107 bg2_res_array_complete_0/sky130_fd_pr__res_high_po_0p35_WZRS6E_0/R2_19_3 bg2_res_array_complete_0/sky130_fd_pr__res_high_po_0p35_WZRS6E_0/R2_19_2 VGND sky130_fd_pr__res_high_po_0p35 l=5
X108 bg2_res_array_complete_0/sky130_fd_pr__res_high_po_0p35_WZRS6E_0/R1_15_5 bg2_res_array_complete_0/sky130_fd_pr__res_high_po_0p35_WZRS6E_0/R2_14_5 VGND sky130_fd_pr__res_high_po_0p35 l=5
X109 VGND VGND VGND sky130_fd_pr__res_high_po_0p35 l=5
X110 bg2_res_array_complete_0/sky130_fd_pr__res_high_po_0p35_WZRS6E_0/R2_24_2 bg2_res_array_complete_0/sky130_fd_pr__res_high_po_0p35_WZRS6E_0/R2_24_1 VGND sky130_fd_pr__res_high_po_0p35 l=5
X111 VGND VGND VGND sky130_fd_pr__res_high_po_0p35 l=5
X112 bg2_res_array_complete_0/sky130_fd_pr__res_high_po_0p35_WZRS6E_0/R2_4_5 bg2_res_array_complete_0/sky130_fd_pr__res_high_po_0p35_WZRS6E_0/R2_4_4 VGND sky130_fd_pr__res_high_po_0p35 l=5
X113 bg2_res_array_complete_0/sky130_fd_pr__res_high_po_0p35_WZRS6E_0/R2_3_4 bg2_res_array_complete_0/sky130_fd_pr__res_high_po_0p35_WZRS6E_0/R2_3_3 VGND sky130_fd_pr__res_high_po_0p35 l=5
X114 VGND VGND VGND sky130_fd_pr__res_high_po_0p35 l=5
X115 VGND VGND VGND sky130_fd_pr__res_high_po_0p35 l=5
X116 VGND VGND VGND sky130_fd_pr__res_high_po_0p35 l=5
X117 VGND VGND VGND sky130_fd_pr__res_high_po_0p35 l=5
X118 VGND VGND VGND sky130_fd_pr__res_high_po_0p35 l=5
X119 bg2_res_array_complete_0/sky130_fd_pr__res_high_po_0p35_WZRS6E_0/R2_14_3 bg2_res_array_complete_0/sky130_fd_pr__res_high_po_0p35_WZRS6E_0/R2_14_2 VGND sky130_fd_pr__res_high_po_0p35 l=5
X120 bg2_res_array_complete_0/sky130_fd_pr__res_high_po_0p35_WZRS6E_0/R1_25_5 bg2_res_array_complete_0/sky130_fd_pr__res_high_po_0p35_WZRS6E_0/R2_24_5 VGND sky130_fd_pr__res_high_po_0p35 l=5
X121 bg2_res_array_complete_0/sky130_fd_pr__res_high_po_0p35_WZRS6E_0/R2_15_4 bg2_res_array_complete_0/sky130_fd_pr__res_high_po_0p35_WZRS6E_0/R2_15_3 VGND sky130_fd_pr__res_high_po_0p35 l=5
X122 VGND VGND VGND sky130_fd_pr__res_high_po_0p35 l=5
X123 VGND VGND VGND sky130_fd_pr__res_high_po_0p35 l=5
X124 VGND VGND VGND sky130_fd_pr__res_high_po_0p35 l=5
X125 bg2_res_array_complete_0/sky130_fd_pr__res_high_po_0p35_WZRS6E_0/R2_12_4 bg2_res_array_complete_0/sky130_fd_pr__res_high_po_0p35_WZRS6E_0/R2_12_3 VGND sky130_fd_pr__res_high_po_0p35 l=5
X126 bg2_res_array_complete_0/sky130_fd_pr__res_high_po_0p35_WZRS6E_0/R1_7_5 bg2_res_array_complete_0/sky130_fd_pr__res_high_po_0p35_WZRS6E_0/R2_7_5 VGND sky130_fd_pr__res_high_po_0p35 l=5
X127 VGND VGND VGND sky130_fd_pr__res_high_po_0p35 l=5
X128 VGND VGND VGND sky130_fd_pr__res_high_po_0p35 l=5
X129 bg2_res_array_complete_0/sky130_fd_pr__res_high_po_0p35_WZRS6E_0/R1_13_1 bg2_res_array_complete_0/sky130_fd_pr__res_high_po_0p35_WZRS6E_0/R2_13_2 VGND sky130_fd_pr__res_high_po_0p35 l=5
X130 VGND VGND VGND sky130_fd_pr__res_high_po_0p35 l=5
X131 VGND VGND VGND sky130_fd_pr__res_high_po_0p35 l=5
X132 bg2_res_array_complete_0/sky130_fd_pr__res_high_po_0p35_WZRS6E_0/R1_13_1 bg2_res_array_complete_0/sky130_fd_pr__res_high_po_0p35_WZRS6E_0/R2_14_1 VGND sky130_fd_pr__res_high_po_0p35 l=5
X133 bg2_res_array_complete_0/sky130_fd_pr__res_high_po_0p35_WZRS6E_0/R1_5_1 bg2_res_array_complete_0/sky130_fd_pr__res_high_po_0p35_WZRS6E_0/R2_6_1 VGND sky130_fd_pr__res_high_po_0p35 l=5
X134 bg2_res_array_complete_0/sky130_fd_pr__res_high_po_0p35_WZRS6E_0/R2_4_3 bg2_res_array_complete_0/sky130_fd_pr__res_high_po_0p35_WZRS6E_0/R2_4_2 VGND sky130_fd_pr__res_high_po_0p35 l=5
X135 bg2_res_array_complete_0/sky130_fd_pr__res_high_po_0p35_WZRS6E_0/R2_26_4 bg2_res_array_complete_0/sky130_fd_pr__res_high_po_0p35_WZRS6E_0/R2_26_3 VGND sky130_fd_pr__res_high_po_0p35 l=5
X136 bg2_res_array_complete_0/sky130_fd_pr__res_high_po_0p35_WZRS6E_0/R2_19_4 bg2_res_array_complete_0/sky130_fd_pr__res_high_po_0p35_WZRS6E_0/R2_19_3 VGND sky130_fd_pr__res_high_po_0p35 l=5
X137 bg2_res_array_complete_0/sky130_fd_pr__res_high_po_0p35_WZRS6E_0/R2_18_5 bg2_res_array_complete_0/sky130_fd_pr__res_high_po_0p35_WZRS6E_0/R2_18_4 VGND sky130_fd_pr__res_high_po_0p35 l=5
X138 bg2_res_array_complete_0/sky130_fd_pr__res_high_po_0p35_WZRS6E_0/R2_15_2 bg2_res_array_complete_0/sky130_fd_pr__res_high_po_0p35_WZRS6E_0/R2_16_1 VGND sky130_fd_pr__res_high_po_0p35 l=5
X139 VGND VGND VGND sky130_fd_pr__res_high_po_0p35 l=5
X140 VGND VGND VGND sky130_fd_pr__res_high_po_0p35 l=5
X141 VGND VGND VGND sky130_fd_pr__res_high_po_0p35 l=5
X142 bg2_res_array_complete_0/sky130_fd_pr__res_high_po_0p35_WZRS6E_0/R1_9_5 bg2_res_array_complete_0/sky130_fd_pr__res_high_po_0p35_WZRS6E_0/R2_9_5 VGND sky130_fd_pr__res_high_po_0p35 l=5
X143 bg2_res_array_complete_0/sky130_fd_pr__res_high_po_0p35_WZRS6E_0/R2_6_5 bg2_res_array_complete_0/sky130_fd_pr__res_high_po_0p35_WZRS6E_0/R2_6_4 VGND sky130_fd_pr__res_high_po_0p35 l=5
X144 bg2_res_array_complete_0/sky130_fd_pr__res_high_po_0p35_WZRS6E_0/R2_5_4 bg2_res_array_complete_0/sky130_fd_pr__res_high_po_0p35_WZRS6E_0/R2_5_3 VGND sky130_fd_pr__res_high_po_0p35 l=5
X145 VGND VGND VGND sky130_fd_pr__res_high_po_0p35 l=5
X146 bg2_res_array_complete_0/sky130_fd_pr__res_high_po_0p35_WZRS6E_0/R1_23_5 bg2_res_array_complete_0/sky130_fd_pr__res_high_po_0p35_WZRS6E_0/R2_22_5 VGND sky130_fd_pr__res_high_po_0p35 l=5
X147 VGND VGND VGND sky130_fd_pr__res_high_po_0p35 l=5
X148 bg2_res_array_complete_0/sky130_fd_pr__res_high_po_0p35_WZRS6E_0/R2_11_3 bg2_res_array_complete_0/sky130_fd_pr__res_high_po_0p35_WZRS6E_0/R2_12_2 VGND sky130_fd_pr__res_high_po_0p35 l=5
X149 VGND VGND VGND sky130_fd_pr__res_high_po_0p35 l=5
X150 bg2_res_array_complete_0/sky130_fd_pr__res_high_po_0p35_WZRS6E_0/R2_10_4 bg2_res_array_complete_0/sky130_fd_pr__res_high_po_0p35_WZRS6E_0/R2_10_3 VGND sky130_fd_pr__res_high_po_0p35 l=5
X151 bg2_res_array_complete_0/sky130_fd_pr__res_high_po_0p35_WZRS6E_0/R2_14_4 bg2_res_array_complete_0/sky130_fd_pr__res_high_po_0p35_WZRS6E_0/R2_14_3 VGND sky130_fd_pr__res_high_po_0p35 l=5
X152 bg2_res_array_complete_0/sky130_fd_pr__res_high_po_0p35_WZRS6E_0/R2_21_3 bg2_res_array_complete_0/sky130_fd_pr__res_high_po_0p35_WZRS6E_0/R2_21_2 VGND sky130_fd_pr__res_high_po_0p35 l=5
X153 VGND VGND VGND sky130_fd_pr__res_high_po_0p35 l=5
X154 VGND VGND VGND sky130_fd_pr__res_high_po_0p35 l=5
X155 bg2_res_array_complete_0/sky130_fd_pr__res_high_po_0p35_WZRS6E_0/R1_25_5 bg2_res_array_complete_0/sky130_fd_pr__res_high_po_0p35_WZRS6E_0/R2_25_5 VGND sky130_fd_pr__res_high_po_0p35 l=5
X156 bg2_res_array_complete_0/sky130_fd_pr__res_high_po_0p35_WZRS6E_0/R1_9_1 bg2_res_array_complete_0/sky130_fd_pr__res_high_po_0p35_WZRS6E_0/R2_9_1 VGND sky130_fd_pr__res_high_po_0p35 l=5
X157 bg2_res_array_complete_0/sky130_fd_pr__res_high_po_0p35_WZRS6E_0/R1_11_1 bg2_res_array_complete_0/sky130_fd_pr__res_high_po_0p35_WZRS6E_0/R2_9_1 VGND sky130_fd_pr__res_high_po_0p35 l=5
X158 VGND VGND VGND sky130_fd_pr__res_high_po_0p35 l=5
X159 bg2_res_array_complete_0/sky130_fd_pr__res_high_po_0p35_WZRS6E_0/R2_18_3 bg2_res_array_complete_0/sky130_fd_pr__res_high_po_0p35_WZRS6E_0/R2_18_2 VGND sky130_fd_pr__res_high_po_0p35 l=5
X160 bg2_res_array_complete_0/sky130_fd_pr__res_high_po_0p35_WZRS6E_0/R2_24_4 bg2_res_array_complete_0/sky130_fd_pr__res_high_po_0p35_WZRS6E_0/R2_24_3 VGND sky130_fd_pr__res_high_po_0p35 l=5
X161 VGND VGND VGND sky130_fd_pr__res_high_po_0p35 l=5
X162 bg2_res_array_complete_0/sky130_fd_pr__res_high_po_0p35_WZRS6E_0/R2_16_5 bg2_res_array_complete_0/sky130_fd_pr__res_high_po_0p35_WZRS6E_0/R2_16_4 VGND sky130_fd_pr__res_high_po_0p35 l=5
X163 bg2_res_array_complete_0/sky130_fd_pr__res_high_po_0p35_WZRS6E_0/R2_23_5 bg2_res_array_complete_0/sky130_fd_pr__res_high_po_0p35_WZRS6E_0/R2_23_4 VGND sky130_fd_pr__res_high_po_0p35 l=5
X164 VGND VGND VGND sky130_fd_pr__res_high_po_0p35 l=5
X165 bg2_res_array_complete_0/sky130_fd_pr__res_high_po_0p35_WZRS6E_0/R2_23_2 bg2_res_array_complete_0/sky130_fd_pr__res_high_po_0p35_WZRS6E_0/R2_24_1 VGND sky130_fd_pr__res_high_po_0p35 l=5
X166 bg2_res_array_complete_0/sky130_fd_pr__res_high_po_0p35_WZRS6E_0/R2_17_3 bg2_res_array_complete_0/sky130_fd_pr__res_high_po_0p35_WZRS6E_0/R2_17_2 VGND sky130_fd_pr__res_high_po_0p35 l=5
X167 VGND VGND VGND sky130_fd_pr__res_high_po_0p35 l=5
X168 VGND VGND VGND sky130_fd_pr__res_high_po_0p35 l=5
X169 bg2_res_array_complete_0/sky130_fd_pr__res_high_po_0p35_WZRS6E_0/R2_7_4 bg2_res_array_complete_0/sky130_fd_pr__res_high_po_0p35_WZRS6E_0/R2_7_3 VGND sky130_fd_pr__res_high_po_0p35 l=5
X170 bg2_res_array_complete_0/sky130_fd_pr__res_high_po_0p35_WZRS6E_0/R1_11_5 bg2_res_array_complete_0/sky130_fd_pr__res_high_po_0p35_WZRS6E_0/R2_11_5 VGND sky130_fd_pr__res_high_po_0p35 l=5
X171 bg2_res_array_complete_0/sky130_fd_pr__res_high_po_0p35_WZRS6E_0/R2_8_5 bg2_res_array_complete_0/sky130_fd_pr__res_high_po_0p35_WZRS6E_0/R2_8_4 VGND sky130_fd_pr__res_high_po_0p35 l=5
X172 VGND VGND VGND sky130_fd_pr__res_high_po_0p35 l=5
X173 bg2_res_array_complete_0/sky130_fd_pr__res_high_po_0p35_WZRS6E_0/R2_8_3 bg2_res_array_complete_0/sky130_fd_pr__res_high_po_0p35_WZRS6E_0/R2_8_2 VGND sky130_fd_pr__res_high_po_0p35 l=5
X174 bg2_res_array_complete_0/sky130_fd_pr__res_high_po_0p35_WZRS6E_0/R1_17_5 bg2_res_array_complete_0/sky130_fd_pr__res_high_po_0p35_WZRS6E_0/R2_17_5 VGND sky130_fd_pr__res_high_po_0p35 l=5
X175 bg2_res_array_complete_0/sky130_fd_pr__res_high_po_0p35_WZRS6E_0/R2_20_2 bg2_res_array_complete_0/sky130_fd_pr__res_high_po_0p35_WZRS6E_0/R2_20_1 VGND sky130_fd_pr__res_high_po_0p35 l=5
X176 VGND VGND VGND sky130_fd_pr__res_high_po_0p35 l=5
X177 VGND VGND VGND sky130_fd_pr__res_high_po_0p35 l=5
X178 bg2_res_array_complete_0/sky130_fd_pr__res_high_po_0p35_WZRS6E_0/R1_3_5 bg2_res_array_complete_0/sky130_fd_pr__res_high_po_0p35_WZRS6E_0/R2_2_5 VGND sky130_fd_pr__res_high_po_0p35 l=5
X179 bg2_res_array_complete_0/sky130_fd_pr__res_high_po_0p35_WZRS6E_0/R2_13_5 bg2_res_array_complete_0/sky130_fd_pr__res_high_po_0p35_WZRS6E_0/R2_13_4 VGND sky130_fd_pr__res_high_po_0p35 l=5
X180 VGND VGND VGND sky130_fd_pr__res_high_po_0p35 l=5
X181 bg2_res_array_complete_0/sky130_fd_pr__res_high_po_0p35_WZRS6E_0/R1_21_5 bg2_res_array_complete_0/sky130_fd_pr__res_high_po_0p35_WZRS6E_0/R2_20_5 VGND sky130_fd_pr__res_high_po_0p35 l=5
X182 VGND VGND VGND sky130_fd_pr__res_high_po_0p35 l=5
X183 bg2_res_array_complete_0/sky130_fd_pr__res_high_po_0p35_WZRS6E_0/R2_25_3 bg2_res_array_complete_0/sky130_fd_pr__res_high_po_0p35_WZRS6E_0/R2_25_2 VGND sky130_fd_pr__res_high_po_0p35 l=5
X184 bg2_res_array_complete_0/sky130_fd_pr__res_high_po_0p35_WZRS6E_0/R1_7_1 bg2_res_array_complete_0/sky130_fd_pr__res_high_po_0p35_WZRS6E_0/R2_6_1 VGND sky130_fd_pr__res_high_po_0p35 l=5
X185 bg2_res_array_complete_0/sky130_fd_pr__res_high_po_0p35_WZRS6E_0/R2_24_3 bg2_res_array_complete_0/sky130_fd_pr__res_high_po_0p35_WZRS6E_0/R2_24_2 VGND sky130_fd_pr__res_high_po_0p35 l=5
X186 VGND VGND VGND sky130_fd_pr__res_high_po_0p35 l=5
X187 bg2_res_array_complete_0/sky130_fd_pr__res_high_po_0p35_WZRS6E_0/R2_9_4 bg2_res_array_complete_0/sky130_fd_pr__res_high_po_0p35_WZRS6E_0/R2_9_3 VGND sky130_fd_pr__res_high_po_0p35 l=5
X188 bg2_res_array_complete_0/sky130_fd_pr__res_high_po_0p35_WZRS6E_0/R1_5_5 bg2_res_array_complete_0/sky130_fd_pr__res_high_po_0p35_WZRS6E_0/R2_4_5 VGND sky130_fd_pr__res_high_po_0p35 l=5
X189 bg2_res_array_complete_0/sky130_fd_pr__res_high_po_0p35_WZRS6E_0/R1_3_1 V_MINUS VGND sky130_fd_pr__res_high_po_0p35 l=5
X190 VGND VGND VGND sky130_fd_pr__res_high_po_0p35 l=5
X191 VGND VGND VGND sky130_fd_pr__res_high_po_0p35 l=5
X192 VGND VGND VGND sky130_fd_pr__res_high_po_0p35 l=5
X193 bg2_res_array_complete_0/sky130_fd_pr__res_high_po_0p35_WZRS6E_0/R2_21_5 bg2_res_array_complete_0/sky130_fd_pr__res_high_po_0p35_WZRS6E_0/R2_21_4 VGND sky130_fd_pr__res_high_po_0p35 l=5
X194 bg2_res_array_complete_0/sky130_fd_pr__res_high_po_0p35_WZRS6E_0/R2_22_4 bg2_res_array_complete_0/sky130_fd_pr__res_high_po_0p35_WZRS6E_0/R2_22_3 VGND sky130_fd_pr__res_high_po_0p35 l=5
X195 VGND VGND VGND sky130_fd_pr__res_high_po_0p35 l=5
X196 bg2_res_array_complete_0/sky130_fd_pr__res_high_po_0p35_WZRS6E_0/R2_26_2 bg2_res_array_complete_0/sky130_fd_pr__res_high_po_0p35_WZRS6E_0/R2_26_1 VGND sky130_fd_pr__res_high_po_0p35 l=5
X197 VGND VGND VGND sky130_fd_pr__res_high_po_0p35 l=5
X198 VGND VGND VGND sky130_fd_pr__res_high_po_0p35 l=5
X199 VGND VGND VGND sky130_fd_pr__res_high_po_0p35 l=5
X200 VGND VGND VGND sky130_fd_pr__res_high_po_0p35 l=5
X201 bg2_res_array_complete_0/sky130_fd_pr__res_high_po_0p35_WZRS6E_0/R2_25_4 bg2_res_array_complete_0/sky130_fd_pr__res_high_po_0p35_WZRS6E_0/R2_25_3 VGND sky130_fd_pr__res_high_po_0p35 l=5
X202 bg2_res_array_complete_0/sky130_fd_pr__res_high_po_0p35_WZRS6E_0/R2_13_3 bg2_res_array_complete_0/sky130_fd_pr__res_high_po_0p35_WZRS6E_0/R2_13_2 VGND sky130_fd_pr__res_high_po_0p35 l=5
X203 bg2_res_array_complete_0/sky130_fd_pr__res_high_po_0p35_WZRS6E_0/R2_12_3 bg2_res_array_complete_0/sky130_fd_pr__res_high_po_0p35_WZRS6E_0/R2_12_2 VGND sky130_fd_pr__res_high_po_0p35 l=5
X204 VGND VGND VGND sky130_fd_pr__res_high_po_0p35 l=5
X205 bg2_res_array_complete_0/sky130_fd_pr__res_high_po_0p35_WZRS6E_0/R2_5_3 bg2_res_array_complete_0/sky130_fd_pr__res_high_po_0p35_WZRS6E_0/R2_6_2 VGND sky130_fd_pr__res_high_po_0p35 l=5
X206 VGND VGND VGND sky130_fd_pr__res_high_po_0p35 l=5
X207 bg2_res_array_complete_0/sky130_fd_pr__res_high_po_0p35_WZRS6E_0/R2_3_5 bg2_res_array_complete_0/sky130_fd_pr__res_high_po_0p35_WZRS6E_0/R2_3_4 VGND sky130_fd_pr__res_high_po_0p35 l=5
X208 bg2_res_array_complete_0/sky130_fd_pr__res_high_po_0p35_WZRS6E_0/R2_15_3 bg2_res_array_complete_0/sky130_fd_pr__res_high_po_0p35_WZRS6E_0/R2_15_2 VGND sky130_fd_pr__res_high_po_0p35 l=5
X209 bg2_res_array_complete_0/sky130_fd_pr__res_high_po_0p35_WZRS6E_0/R1_19_5 bg2_res_array_complete_0/sky130_fd_pr__res_high_po_0p35_WZRS6E_0/R2_18_5 VGND sky130_fd_pr__res_high_po_0p35 l=5
X210 VGND VGND VGND sky130_fd_pr__res_high_po_0p35 l=5
X211 VGND VGND VGND sky130_fd_pr__res_high_po_0p35 l=5
X212 bg2_res_array_complete_0/sky130_fd_pr__res_high_po_0p35_WZRS6E_0/R2_15_5 bg2_res_array_complete_0/sky130_fd_pr__res_high_po_0p35_WZRS6E_0/R2_15_4 VGND sky130_fd_pr__res_high_po_0p35 l=5
X213 bg2_res_array_complete_0/sky130_fd_pr__res_high_po_0p35_WZRS6E_0/R1_3_1 bg2_res_array_complete_0/sky130_fd_pr__res_high_po_0p35_WZRS6E_0/R2_4_1 VGND sky130_fd_pr__res_high_po_0p35 l=5
X214 VGND VGND VGND sky130_fd_pr__res_high_po_0p35 l=5
X215 bg2_res_array_complete_0/sky130_fd_pr__res_high_po_0p35_WZRS6E_0/R2_11_4 bg2_res_array_complete_0/sky130_fd_pr__res_high_po_0p35_WZRS6E_0/R2_11_3 VGND sky130_fd_pr__res_high_po_0p35 l=5
X216 bg2_res_array_complete_0/sky130_fd_pr__res_high_po_0p35_WZRS6E_0/R2_16_2 bg2_res_array_complete_0/sky130_fd_pr__res_high_po_0p35_WZRS6E_0/R2_16_1 VGND sky130_fd_pr__res_high_po_0p35 l=5
X217 bg2_res_array_complete_0/sky130_fd_pr__res_high_po_0p35_WZRS6E_0/R1_7_5 bg2_res_array_complete_0/sky130_fd_pr__res_high_po_0p35_WZRS6E_0/R2_6_5 VGND sky130_fd_pr__res_high_po_0p35 l=5
X218 bg2_res_array_complete_0/sky130_fd_pr__res_high_po_0p35_WZRS6E_0/R2_12_5 bg2_res_array_complete_0/sky130_fd_pr__res_high_po_0p35_WZRS6E_0/R2_12_4 VGND sky130_fd_pr__res_high_po_0p35 l=5
X219 bg2_res_array_complete_0/sky130_fd_pr__res_high_po_0p35_WZRS6E_0/R2_17_4 bg2_res_array_complete_0/sky130_fd_pr__res_high_po_0p35_WZRS6E_0/R2_17_3 VGND sky130_fd_pr__res_high_po_0p35 l=5
X220 VGND VGND VGND sky130_fd_pr__res_high_po_0p35 l=5
X221 VGND VGND VGND sky130_fd_pr__res_high_po_0p35 l=5
X222 bg2_res_array_complete_0/sky130_fd_pr__res_high_po_0p35_WZRS6E_0/R2_2_4 bg2_res_array_complete_0/sky130_fd_pr__res_high_po_0p35_WZRS6E_0/R2_2_3 VGND sky130_fd_pr__res_high_po_0p35 l=5
X223 VGND VGND VGND sky130_fd_pr__res_high_po_0p35 l=5
X224 bg2_res_array_complete_0/sky130_fd_pr__res_high_po_0p35_WZRS6E_0/R2_20_4 bg2_res_array_complete_0/sky130_fd_pr__res_high_po_0p35_WZRS6E_0/R2_20_3 VGND sky130_fd_pr__res_high_po_0p35 l=5
X225 bg2_res_array_complete_0/sky130_fd_pr__res_high_po_0p35_WZRS6E_0/R2_19_5 bg2_res_array_complete_0/sky130_fd_pr__res_high_po_0p35_WZRS6E_0/R2_19_4 VGND sky130_fd_pr__res_high_po_0p35 l=5
X226 bg2_res_array_complete_0/sky130_fd_pr__res_high_po_0p35_WZRS6E_0/R2_26_5 bg2_res_array_complete_0/sky130_fd_pr__res_high_po_0p35_WZRS6E_0/R2_26_4 VGND sky130_fd_pr__res_high_po_0p35 l=5
X227 VGND VGND VGND sky130_fd_pr__res_high_po_0p35 l=5
X228 VGND VGND VGND sky130_fd_pr__res_high_po_0p35 l=5
X229 VGND VGND VGND sky130_fd_pr__res_high_po_0p35 l=5
X230 bg2_res_array_complete_0/sky130_fd_pr__res_high_po_0p35_WZRS6E_0/R2_4_4 bg2_res_array_complete_0/sky130_fd_pr__res_high_po_0p35_WZRS6E_0/R2_4_3 VGND sky130_fd_pr__res_high_po_0p35 l=5
X231 bg2_res_array_complete_0/sky130_fd_pr__res_high_po_0p35_WZRS6E_0/R2_9_3 bg2_res_array_complete_0/sky130_fd_pr__res_high_po_0p35_WZRS6E_0/R2_9_2 VGND sky130_fd_pr__res_high_po_0p35 l=5
X232 bg2_res_array_complete_0/sky130_fd_pr__res_high_po_0p35_WZRS6E_0/R2_10_3 bg2_res_array_complete_0/sky130_fd_pr__res_high_po_0p35_WZRS6E_0/R2_9_2 VGND sky130_fd_pr__res_high_po_0p35 l=5
X233 VGND VGND VGND sky130_fd_pr__res_high_po_0p35 l=5
X234 bg2_res_array_complete_0/sky130_fd_pr__res_high_po_0p35_WZRS6E_0/R2_5_5 bg2_res_array_complete_0/sky130_fd_pr__res_high_po_0p35_WZRS6E_0/R2_5_4 VGND sky130_fd_pr__res_high_po_0p35 l=5
X235 VGND VGND VGND sky130_fd_pr__res_high_po_0p35 l=5
X236 bg2_res_array_complete_0/sky130_fd_pr__res_high_po_0p35_WZRS6E_0/R2_22_2 bg2_res_array_complete_0/sky130_fd_pr__res_high_po_0p35_WZRS6E_0/R2_22_1 VGND sky130_fd_pr__res_high_po_0p35 l=5
X237 bg2_res_array_complete_0/sky130_fd_pr__res_high_po_0p35_WZRS6E_0/R2_23_3 bg2_res_array_complete_0/sky130_fd_pr__res_high_po_0p35_WZRS6E_0/R2_23_2 VGND sky130_fd_pr__res_high_po_0p35 l=5
X238 bg2_res_array_complete_0/sky130_fd_pr__res_high_po_0p35_WZRS6E_0/R1_23_5 bg2_res_array_complete_0/sky130_fd_pr__res_high_po_0p35_WZRS6E_0/R2_23_5 VGND sky130_fd_pr__res_high_po_0p35 l=5
X239 bg2_res_array_complete_0/sky130_fd_pr__res_high_po_0p35_WZRS6E_0/R1_7_1 bg2_res_array_complete_0/sky130_fd_pr__res_high_po_0p35_WZRS6E_0/R2_8_1 VGND sky130_fd_pr__res_high_po_0p35 l=5
X240 bg2_res_array_complete_0/sky130_fd_pr__res_high_po_0p35_WZRS6E_0/R1_17_5 bg2_res_array_complete_0/sky130_fd_pr__res_high_po_0p35_WZRS6E_0/R2_16_5 VGND sky130_fd_pr__res_high_po_0p35 l=5
X241 bg2_res_array_complete_0/sky130_fd_pr__res_high_po_0p35_WZRS6E_0/R2_10_5 bg2_res_array_complete_0/sky130_fd_pr__res_high_po_0p35_WZRS6E_0/R2_10_4 VGND sky130_fd_pr__res_high_po_0p35 l=5
X242 VGND VGND VGND sky130_fd_pr__res_high_po_0p35 l=5
X243 bg2_res_array_complete_0/sky130_fd_pr__res_high_po_0p35_WZRS6E_0/R2_14_5 bg2_res_array_complete_0/sky130_fd_pr__res_high_po_0p35_WZRS6E_0/R2_14_4 VGND sky130_fd_pr__res_high_po_0p35 l=5
X244 bg2_res_array_complete_0/sky130_fd_pr__res_high_po_0p35_WZRS6E_0/R1_9_5 bg2_res_array_complete_0/sky130_fd_pr__res_high_po_0p35_WZRS6E_0/R2_8_5 VGND sky130_fd_pr__res_high_po_0p35 l=5
X245 VGND VGND VGND sky130_fd_pr__res_high_po_0p35 l=5
X246 VGND VGND VGND sky130_fd_pr__res_high_po_0p35 l=5
X247 VGND VGND VGND sky130_fd_pr__res_high_po_0p35 l=5
X248 bg2_res_array_complete_0/sky130_fd_pr__res_high_po_0p35_WZRS6E_0/R2_19_2 bg2_res_array_complete_0/sky130_fd_pr__res_high_po_0p35_WZRS6E_0/R2_20_1 VGND sky130_fd_pr__res_high_po_0p35 l=5
X249 bg2_res_array_complete_0/sky130_fd_pr__res_high_po_0p35_WZRS6E_0/R2_20_3 bg2_res_array_complete_0/sky130_fd_pr__res_high_po_0p35_WZRS6E_0/R2_20_2 VGND sky130_fd_pr__res_high_po_0p35 l=5
X250 VGND VGND VGND sky130_fd_pr__res_high_po_0p35 l=5
X251 bg2_res_array_complete_0/sky130_fd_pr__res_high_po_0p35_WZRS6E_0/R1_27_5 bg2_bjt_array_0/VE_VREF VGND sky130_fd_pr__res_high_po_0p35 l=5
X252 VGND VGND VGND sky130_fd_pr__res_high_po_0p35 l=5
X253 VGND VGND VGND sky130_fd_pr__res_high_po_0p35 l=5
X254 VGND VGND VGND sky130_fd_pr__pnp_05v5_W3p40L3p40
X255 VGND VGND VGND sky130_fd_pr__pnp_05v5_W3p40L3p40
X256 VGND VGND VGND sky130_fd_pr__pnp_05v5_W3p40L3p40
X257 VGND VGND VGND sky130_fd_pr__pnp_05v5_W3p40L3p40
X258 VGND VGND VGND sky130_fd_pr__pnp_05v5_W3p40L3p40
X259 VGND VGND VGND sky130_fd_pr__pnp_05v5_W3p40L3p40
X260 VGND VGND V_PLUS sky130_fd_pr__pnp_05v5_W3p40L3p40
X261 VGND VGND VGND sky130_fd_pr__pnp_05v5_W3p40L3p40
X262 VGND VGND VGND sky130_fd_pr__pnp_05v5_W3p40L3p40
X263 VGND VGND bg2_bjt_array_0/VE_VREF sky130_fd_pr__pnp_05v5_W3p40L3p40
X264 VGND VGND bg2_bjt_array_0/VE_MINUS sky130_fd_pr__pnp_05v5_W3p40L3p40
X265 VGND VGND VGND sky130_fd_pr__pnp_05v5_W3p40L3p40
X266 VGND VGND VGND sky130_fd_pr__pnp_05v5_W3p40L3p40
X267 VGND VGND bg2_bjt_array_0/VE_VREF sky130_fd_pr__pnp_05v5_W3p40L3p40
X268 VGND VGND bg2_bjt_array_0/VE_MINUS sky130_fd_pr__pnp_05v5_W3p40L3p40
X269 VGND VGND VGND sky130_fd_pr__pnp_05v5_W3p40L3p40
X270 VGND VGND VGND sky130_fd_pr__pnp_05v5_W3p40L3p40
X271 VGND VGND bg2_bjt_array_0/VE_VREF sky130_fd_pr__pnp_05v5_W3p40L3p40
X272 VGND VGND bg2_bjt_array_0/VE_MINUS sky130_fd_pr__pnp_05v5_W3p40L3p40
X273 VGND VGND VGND sky130_fd_pr__pnp_05v5_W3p40L3p40
X274 VGND VGND VGND sky130_fd_pr__pnp_05v5_W3p40L3p40
X275 VGND VGND bg2_bjt_array_0/VE_VREF sky130_fd_pr__pnp_05v5_W3p40L3p40
X276 VGND VGND bg2_bjt_array_0/VE_MINUS sky130_fd_pr__pnp_05v5_W3p40L3p40
X277 VGND VGND VGND sky130_fd_pr__pnp_05v5_W3p40L3p40
X278 VGND VGND VGND sky130_fd_pr__pnp_05v5_W3p40L3p40
X279 VGND VGND bg2_bjt_array_0/VE_VREF sky130_fd_pr__pnp_05v5_W3p40L3p40
X280 VGND VGND bg2_bjt_array_0/VE_MINUS sky130_fd_pr__pnp_05v5_W3p40L3p40
X281 VGND VGND VGND sky130_fd_pr__pnp_05v5_W3p40L3p40
X282 VGND VGND VGND sky130_fd_pr__pnp_05v5_W3p40L3p40
X283 VGND VGND bg2_bjt_array_0/VE_VREF sky130_fd_pr__pnp_05v5_W3p40L3p40
X284 VGND VGND bg2_bjt_array_0/VE_MINUS sky130_fd_pr__pnp_05v5_W3p40L3p40
X285 VGND VGND VGND sky130_fd_pr__pnp_05v5_W3p40L3p40
X286 VGND VGND VGND sky130_fd_pr__pnp_05v5_W3p40L3p40
X287 VGND VGND bg2_bjt_array_0/VE_VREF sky130_fd_pr__pnp_05v5_W3p40L3p40
X288 VGND VGND bg2_bjt_array_0/VE_MINUS sky130_fd_pr__pnp_05v5_W3p40L3p40
X289 VGND VGND VGND sky130_fd_pr__pnp_05v5_W3p40L3p40
X290 VGND VGND VGND sky130_fd_pr__pnp_05v5_W3p40L3p40
X291 VGND VGND bg2_bjt_array_0/VE_VREF sky130_fd_pr__pnp_05v5_W3p40L3p40
X292 VGND VGND bg2_bjt_array_0/VE_MINUS sky130_fd_pr__pnp_05v5_W3p40L3p40
X293 VGND VGND VGND sky130_fd_pr__pnp_05v5_W3p40L3p40
X294 VGND VGND VGND sky130_fd_pr__pnp_05v5_W3p40L3p40
X295 VGND VGND VGND sky130_fd_pr__pnp_05v5_W3p40L3p40
X296 VGND VGND VGND sky130_fd_pr__pnp_05v5_W3p40L3p40
X297 VGND VGND VGND sky130_fd_pr__pnp_05v5_W3p40L3p40
