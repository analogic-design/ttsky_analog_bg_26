* SPICE3 file created from bg2_bjt_array_lvs.ext - technology: sky130A

X0 AVSS AVSS AVSS sky130_fd_pr__pnp_05v5_W3p40L3p40
X1 AVSS AVSS AVSS sky130_fd_pr__pnp_05v5_W3p40L3p40
X2 AVSS AVSS AVSS sky130_fd_pr__pnp_05v5_W3p40L3p40
X3 AVSS AVSS AVSS sky130_fd_pr__pnp_05v5_W3p40L3p40
X4 AVSS AVSS AVSS sky130_fd_pr__pnp_05v5_W3p40L3p40
X5 AVSS AVSS AVSS sky130_fd_pr__pnp_05v5_W3p40L3p40
X6 AVSS AVSS V_PLUS sky130_fd_pr__pnp_05v5_W3p40L3p40
X7 AVSS AVSS AVSS sky130_fd_pr__pnp_05v5_W3p40L3p40
X8 AVSS AVSS AVSS sky130_fd_pr__pnp_05v5_W3p40L3p40
X9 AVSS AVSS VE_VREF sky130_fd_pr__pnp_05v5_W3p40L3p40
X10 AVSS AVSS VE_MINUS sky130_fd_pr__pnp_05v5_W3p40L3p40
X11 AVSS AVSS AVSS sky130_fd_pr__pnp_05v5_W3p40L3p40
X12 AVSS AVSS AVSS sky130_fd_pr__pnp_05v5_W3p40L3p40
X13 AVSS AVSS VE_VREF sky130_fd_pr__pnp_05v5_W3p40L3p40
X14 AVSS AVSS VE_MINUS sky130_fd_pr__pnp_05v5_W3p40L3p40
X15 AVSS AVSS AVSS sky130_fd_pr__pnp_05v5_W3p40L3p40
X16 AVSS AVSS AVSS sky130_fd_pr__pnp_05v5_W3p40L3p40
X17 AVSS AVSS VE_VREF sky130_fd_pr__pnp_05v5_W3p40L3p40
X18 AVSS AVSS VE_MINUS sky130_fd_pr__pnp_05v5_W3p40L3p40
X19 AVSS AVSS AVSS sky130_fd_pr__pnp_05v5_W3p40L3p40
X20 AVSS AVSS AVSS sky130_fd_pr__pnp_05v5_W3p40L3p40
X21 AVSS AVSS VE_VREF sky130_fd_pr__pnp_05v5_W3p40L3p40
X22 AVSS AVSS VE_MINUS sky130_fd_pr__pnp_05v5_W3p40L3p40
X23 AVSS AVSS AVSS sky130_fd_pr__pnp_05v5_W3p40L3p40
X24 AVSS AVSS AVSS sky130_fd_pr__pnp_05v5_W3p40L3p40
X25 AVSS AVSS VE_VREF sky130_fd_pr__pnp_05v5_W3p40L3p40
X26 AVSS AVSS VE_MINUS sky130_fd_pr__pnp_05v5_W3p40L3p40
X27 AVSS AVSS AVSS sky130_fd_pr__pnp_05v5_W3p40L3p40
X28 AVSS AVSS AVSS sky130_fd_pr__pnp_05v5_W3p40L3p40
X29 AVSS AVSS VE_VREF sky130_fd_pr__pnp_05v5_W3p40L3p40
X30 AVSS AVSS VE_MINUS sky130_fd_pr__pnp_05v5_W3p40L3p40
X31 AVSS AVSS AVSS sky130_fd_pr__pnp_05v5_W3p40L3p40
X32 AVSS AVSS AVSS sky130_fd_pr__pnp_05v5_W3p40L3p40
X33 AVSS AVSS VE_VREF sky130_fd_pr__pnp_05v5_W3p40L3p40
X34 AVSS AVSS VE_MINUS sky130_fd_pr__pnp_05v5_W3p40L3p40
X35 AVSS AVSS AVSS sky130_fd_pr__pnp_05v5_W3p40L3p40
X36 AVSS AVSS AVSS sky130_fd_pr__pnp_05v5_W3p40L3p40
X37 AVSS AVSS VE_VREF sky130_fd_pr__pnp_05v5_W3p40L3p40
X38 AVSS AVSS VE_MINUS sky130_fd_pr__pnp_05v5_W3p40L3p40
X39 AVSS AVSS AVSS sky130_fd_pr__pnp_05v5_W3p40L3p40
X40 AVSS AVSS AVSS sky130_fd_pr__pnp_05v5_W3p40L3p40
X41 AVSS AVSS AVSS sky130_fd_pr__pnp_05v5_W3p40L3p40
X42 AVSS AVSS AVSS sky130_fd_pr__pnp_05v5_W3p40L3p40
X43 AVSS AVSS AVSS sky130_fd_pr__pnp_05v5_W3p40L3p40
