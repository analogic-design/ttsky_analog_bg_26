* SPICE3 file created from bg2_opamp_lvs.ext - technology: sky130A

X0 vb vb VDDA VDDA sky130_fd_pr__pfet_01v8_lvt ad=1.16 pd=8.58 as=1.16 ps=8.58 w=4 l=6
X1 VDDA vb V_OUT VDDA sky130_fd_pr__pfet_01v8_lvt ad=3.48003 pd=25.745 as=1.16003 ps=8.585 w=4 l=6
X2 V_OUT vb VDDA VDDA sky130_fd_pr__pfet_01v8_lvt ad=1.16 pd=8.58 as=1.16 ps=8.58 w=4 l=6
X3 vb V_PLUS vs VSSA sky130_fd_pr__nfet_01v8 ad=1.16 pd=8.58 as=1.16 ps=8.58 w=4 l=6
X4 vs V_PLUS vb VSSA sky130_fd_pr__nfet_01v8 ad=1.16 pd=8.58 as=1.16 ps=8.58 w=4 l=6
X5 VDDA vb vb VDDA sky130_fd_pr__pfet_01v8_lvt ad=1.16 pd=8.58 as=1.16 ps=8.58 w=4 l=6
X6 V_OUT V_MINUS vs VSSA sky130_fd_pr__nfet_01v8 ad=1.16 pd=8.58 as=1.16 ps=8.58 w=4 l=6
X7 vs V_MINUS V_OUT VSSA sky130_fd_pr__nfet_01v8 ad=1.16 pd=8.58 as=1.16 ps=8.58 w=4 l=6
X8 VSSA vb vs VSSA sky130_fd_pr__nfet_01v8 ad=0.145 pd=1.58 as=0.145 ps=1.58 w=0.5 l=10
X9 vs vb VSSA VSSA sky130_fd_pr__nfet_01v8 ad=0.145 pd=1.58 as=0.145 ps=1.58 w=0.5 l=10
