* SPICE3 file created from bg2_top_tt_v4_lvs.ext - technology: sky130A

X0 VGND VPWR VGND VGND sky130_fd_pr__nfet_01v8 ad=2.9 pd=20.58 as=2.9 ps=20.58 w=10 l=10
X1 VGND VPWR VGND VGND sky130_fd_pr__nfet_01v8 ad=2.9 pd=20.58 as=2.9 ps=20.58 w=10 l=10
X2 VGND VPWR VGND VGND sky130_fd_pr__nfet_01v8 ad=2.9 pd=20.58 as=2.9 ps=20.58 w=10 l=10
X3 VGND VPWR VGND VGND sky130_fd_pr__nfet_01v8 ad=2.9 pd=20.58 as=2.9 ps=20.58 w=10 l=10
X4 VGND VPWR VGND VGND sky130_fd_pr__nfet_01v8 ad=2.9 pd=20.58 as=2.9 ps=20.58 w=10 l=10
X5 VGND VPWR VGND VGND sky130_fd_pr__nfet_01v8 ad=2.9 pd=20.58 as=2.9 ps=20.58 w=10 l=10
X6 VGND VPWR VGND VGND sky130_fd_pr__nfet_01v8 ad=2.9 pd=20.58 as=2.9 ps=20.58 w=10 l=10
X7 VGND VPWR VGND VGND sky130_fd_pr__nfet_01v8 ad=2.9 pd=20.58 as=2.9 ps=20.58 w=10 l=10
X8 VGND VPWR VGND VGND sky130_fd_pr__nfet_01v8 ad=2.9 pd=20.58 as=2.9 ps=20.58 w=10 l=10
X9 VGND VPWR VGND VGND sky130_fd_pr__nfet_01v8 ad=2.9 pd=20.58 as=2.9 ps=20.58 w=10 l=10
X10 VPWR VPWR VPWR VPWR sky130_fd_pr__pfet_01v8_lvt ad=1.16 pd=8.58 as=1.16 ps=8.58 w=4 l=6
X11 V_PLUS vbp1 VPWR VPWR sky130_fd_pr__pfet_01v8_lvt ad=2.32002 pd=17.165 as=69.60002 ps=497.405 w=4 l=6
X12 VPWR vbp1 V_PLUS VPWR sky130_fd_pr__pfet_01v8_lvt ad=0 pd=0 as=0 ps=0 w=4 l=6
X13 V_MINUS vbp1 VPWR VPWR sky130_fd_pr__pfet_01v8_lvt ad=1.16003 pd=8.585 as=0 ps=0 w=4 l=6
X14 V_REF vbp1 VPWR VPWR sky130_fd_pr__pfet_01v8_lvt ad=1.16003 pd=8.585 as=0 ps=0 w=4 l=6
X15 VPWR vbp1 V_MINUS VPWR sky130_fd_pr__pfet_01v8_lvt ad=0 pd=0 as=0 ps=0 w=4 l=6
X16 VPWR vbp1 V_REF VPWR sky130_fd_pr__pfet_01v8_lvt ad=0 pd=0 as=0 ps=0 w=4 l=6
X17 VPWR VPWR VPWR VPWR sky130_fd_pr__pfet_01v8_lvt ad=0 pd=0 as=0 ps=0 w=4 l=6
X18 VPWR VPWR VPWR VPWR sky130_fd_pr__pfet_01v8_lvt ad=1.16 pd=8.58 as=1.16 ps=8.58 w=4 l=6
X19 VPWR VPWR VPWR VPWR sky130_fd_pr__pfet_01v8_lvt ad=1.16 pd=8.58 as=1.16 ps=8.58 w=4 l=6
X20 VPWR vbp1 VPWR VPWR sky130_fd_pr__pfet_01v8_lvt ad=2.9 pd=20.58 as=2.9 ps=20.58 w=10 l=10
X21 VPWR vbp1 VPWR VPWR sky130_fd_pr__pfet_01v8_lvt ad=2.9 pd=20.58 as=2.9 ps=20.58 w=10 l=10
X22 VPWR vbp1 VPWR VPWR sky130_fd_pr__pfet_01v8_lvt ad=2.9 pd=20.58 as=2.9 ps=20.58 w=10 l=10
X23 VPWR vbp1 VPWR VPWR sky130_fd_pr__pfet_01v8_lvt ad=2.9 pd=20.58 as=2.9 ps=20.58 w=10 l=10
X24 VPWR vbp1 VPWR VPWR sky130_fd_pr__pfet_01v8_lvt ad=2.9 pd=20.58 as=2.9 ps=20.58 w=10 l=10
X25 VPWR vbp1 VPWR VPWR sky130_fd_pr__pfet_01v8_lvt ad=2.9 pd=20.58 as=2.9 ps=20.58 w=10 l=10
X26 VPWR vbp1 VPWR VPWR sky130_fd_pr__pfet_01v8_lvt ad=2.9 pd=20.58 as=2.9 ps=20.58 w=10 l=10
X27 VPWR vbp1 VPWR VPWR sky130_fd_pr__pfet_01v8_lvt ad=2.9 pd=20.58 as=2.9 ps=20.58 w=10 l=10
X28 VPWR vbp1 VPWR VPWR sky130_fd_pr__pfet_01v8_lvt ad=2.9 pd=20.58 as=2.9 ps=20.58 w=10 l=10
X29 VPWR vbp1 VPWR VPWR sky130_fd_pr__pfet_01v8_lvt ad=2.9 pd=20.58 as=2.9 ps=20.58 w=10 l=10
X30 bg2_startup_0/sky130_fd_pr__nfet_01v8_BH8H9B_0/G vbp1 VPWR VPWR sky130_fd_pr__pfet_01v8_lvt ad=1.16 pd=8.58 as=1.16 ps=8.58 w=4 l=6
X31 VGND bg2_startup_0/sky130_fd_pr__nfet_01v8_BH8H9B_0/G bg2_startup_0/sky130_fd_pr__nfet_01v8_BH8H9B_0/G VGND sky130_fd_pr__nfet_01v8 ad=0.29 pd=2.58 as=0.29 ps=2.58 w=1 l=100
X32 VPWR vbp1 bg2_startup_0/sky130_fd_pr__nfet_01v8_BH8H9B_0/G VPWR sky130_fd_pr__pfet_01v8_lvt ad=1.16 pd=8.58 as=1.16 ps=8.58 w=4 l=6
X33 V_PLUS bg2_startup_0/sky130_fd_pr__nfet_01v8_BH8H9B_0/G vbp1 VPWR sky130_fd_pr__pfet_01v8_lvt ad=1.16 pd=8.58 as=1.16 ps=8.58 w=4 l=3
