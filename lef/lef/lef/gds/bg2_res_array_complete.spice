** sch_path: /home/lenny/projects/test/layout/bg2_res_array_complete.sch
**.subckt bg2_res_array_complete V_MINUS VREF AVSS VE_VREF VE_VMINUS
*.ipin V_MINUS
*.opin VE_VMINUS
*.ipin AVSS
*.ipin VREF
*.opin VE_VREF
XR1 net1 V_MINUS AVSS sky130_fd_pr__res_high_po_0p35 L=5 mult=1
XR2 net2 net1 AVSS sky130_fd_pr__res_high_po_0p35 L=5 mult=1
XR3 net3 net2 AVSS sky130_fd_pr__res_high_po_0p35 L=5 mult=1
XR4 net4 net3 AVSS sky130_fd_pr__res_high_po_0p35 L=5 mult=1
XR5 net5 net4 AVSS sky130_fd_pr__res_high_po_0p35 L=5 mult=1
XR6 net6 net5 AVSS sky130_fd_pr__res_high_po_0p35 L=5 mult=1
XR7 net7 net6 AVSS sky130_fd_pr__res_high_po_0p35 L=5 mult=1
XR8 net8 net7 AVSS sky130_fd_pr__res_high_po_0p35 L=5 mult=1
XR9 net9 net8 AVSS sky130_fd_pr__res_high_po_0p35 L=5 mult=1
XR10 VE_VMINUS net9 AVSS sky130_fd_pr__res_high_po_0p35 L=5 mult=1
XR11 net10 VREF AVSS sky130_fd_pr__res_high_po_0p35 L=5 mult=1
XR12 net11 net10 AVSS sky130_fd_pr__res_high_po_0p35 L=5 mult=1
XR13 net12 net11 AVSS sky130_fd_pr__res_high_po_0p35 L=5 mult=1
XR14 net13 net12 AVSS sky130_fd_pr__res_high_po_0p35 L=5 mult=1
XR15 net14 net13 AVSS sky130_fd_pr__res_high_po_0p35 L=5 mult=1
XR16 net15 net14 AVSS sky130_fd_pr__res_high_po_0p35 L=5 mult=1
XR17 net16 net15 AVSS sky130_fd_pr__res_high_po_0p35 L=5 mult=1
XR18 net17 net16 AVSS sky130_fd_pr__res_high_po_0p35 L=5 mult=1
XR19 net18 net17 AVSS sky130_fd_pr__res_high_po_0p35 L=5 mult=1
XR20 net19 net18 AVSS sky130_fd_pr__res_high_po_0p35 L=5 mult=1
XR21 net20 net19 AVSS sky130_fd_pr__res_high_po_0p35 L=5 mult=1
XR22 net21 net20 AVSS sky130_fd_pr__res_high_po_0p35 L=5 mult=1
XR23 net22 net21 AVSS sky130_fd_pr__res_high_po_0p35 L=5 mult=1
XR24 net23 net22 AVSS sky130_fd_pr__res_high_po_0p35 L=5 mult=1
XR25 net24 net23 AVSS sky130_fd_pr__res_high_po_0p35 L=5 mult=1
XR26 net25 net24 AVSS sky130_fd_pr__res_high_po_0p35 L=5 mult=1
XR27 net26 net25 AVSS sky130_fd_pr__res_high_po_0p35 L=5 mult=1
XR28 net27 net26 AVSS sky130_fd_pr__res_high_po_0p35 L=5 mult=1
XR29 net28 net27 AVSS sky130_fd_pr__res_high_po_0p35 L=5 mult=1
XR30 net29 net28 AVSS sky130_fd_pr__res_high_po_0p35 L=5 mult=1
XR31 net30 net29 AVSS sky130_fd_pr__res_high_po_0p35 L=5 mult=1
XR32 net31 net30 AVSS sky130_fd_pr__res_high_po_0p35 L=5 mult=1
XR33 net32 net31 AVSS sky130_fd_pr__res_high_po_0p35 L=5 mult=1
XR34 net33 net32 AVSS sky130_fd_pr__res_high_po_0p35 L=5 mult=1
XR35 net34 net33 AVSS sky130_fd_pr__res_high_po_0p35 L=5 mult=1
XR36 net35 net34 AVSS sky130_fd_pr__res_high_po_0p35 L=5 mult=1
XR37 net36 net35 AVSS sky130_fd_pr__res_high_po_0p35 L=5 mult=1
XR38 net37 net36 AVSS sky130_fd_pr__res_high_po_0p35 L=5 mult=1
XR39 net38 net37 AVSS sky130_fd_pr__res_high_po_0p35 L=5 mult=1
XR40 net39 net38 AVSS sky130_fd_pr__res_high_po_0p35 L=5 mult=1
XR41 net40 net39 AVSS sky130_fd_pr__res_high_po_0p35 L=5 mult=1
XR42 net41 net40 AVSS sky130_fd_pr__res_high_po_0p35 L=5 mult=1
XR43 net42 net41 AVSS sky130_fd_pr__res_high_po_0p35 L=5 mult=1
XR44 net43 net42 AVSS sky130_fd_pr__res_high_po_0p35 L=5 mult=1
XR45 net44 net43 AVSS sky130_fd_pr__res_high_po_0p35 L=5 mult=1
XR46 net45 net44 AVSS sky130_fd_pr__res_high_po_0p35 L=5 mult=1
XR47 net46 net45 AVSS sky130_fd_pr__res_high_po_0p35 L=5 mult=1
XR48 net47 net46 AVSS sky130_fd_pr__res_high_po_0p35 L=5 mult=1
XR49 net48 net47 AVSS sky130_fd_pr__res_high_po_0p35 L=5 mult=1
XR50 net49 net48 AVSS sky130_fd_pr__res_high_po_0p35 L=5 mult=1
XR51 net50 net49 AVSS sky130_fd_pr__res_high_po_0p35 L=5 mult=1
XR52 net51 net50 AVSS sky130_fd_pr__res_high_po_0p35 L=5 mult=1
XR53 net52 net51 AVSS sky130_fd_pr__res_high_po_0p35 L=5 mult=1
XR54 net53 net52 AVSS sky130_fd_pr__res_high_po_0p35 L=5 mult=1
XR55 net54 net53 AVSS sky130_fd_pr__res_high_po_0p35 L=5 mult=1
XR56 net55 net54 AVSS sky130_fd_pr__res_high_po_0p35 L=5 mult=1
XR57 net56 net55 AVSS sky130_fd_pr__res_high_po_0p35 L=5 mult=1
XR58 net57 net56 AVSS sky130_fd_pr__res_high_po_0p35 L=5 mult=1
XR59 net58 net57 AVSS sky130_fd_pr__res_high_po_0p35 L=5 mult=1
XR60 net59 net58 AVSS sky130_fd_pr__res_high_po_0p35 L=5 mult=1
XR61 net60 net59 AVSS sky130_fd_pr__res_high_po_0p35 L=5 mult=1
XR62 net61 net60 AVSS sky130_fd_pr__res_high_po_0p35 L=5 mult=1
XR63 net62 net61 AVSS sky130_fd_pr__res_high_po_0p35 L=5 mult=1
XR64 net63 net62 AVSS sky130_fd_pr__res_high_po_0p35 L=5 mult=1
XR65 net64 net63 AVSS sky130_fd_pr__res_high_po_0p35 L=5 mult=1
XR66 net65 net64 AVSS sky130_fd_pr__res_high_po_0p35 L=5 mult=1
XR67 net66 net65 AVSS sky130_fd_pr__res_high_po_0p35 L=5 mult=1
XR68 net67 net66 AVSS sky130_fd_pr__res_high_po_0p35 L=5 mult=1
XR69 net68 net67 AVSS sky130_fd_pr__res_high_po_0p35 L=5 mult=1
XR70 net69 net68 AVSS sky130_fd_pr__res_high_po_0p35 L=5 mult=1
XR71 net70 net69 AVSS sky130_fd_pr__res_high_po_0p35 L=5 mult=1
XR72 net71 net70 AVSS sky130_fd_pr__res_high_po_0p35 L=5 mult=1
XR73 net72 net71 AVSS sky130_fd_pr__res_high_po_0p35 L=5 mult=1
XR74 net73 net72 AVSS sky130_fd_pr__res_high_po_0p35 L=5 mult=1
XR75 net74 net73 AVSS sky130_fd_pr__res_high_po_0p35 L=5 mult=1
XR76 net75 net74 AVSS sky130_fd_pr__res_high_po_0p35 L=5 mult=1
XR77 net76 net75 AVSS sky130_fd_pr__res_high_po_0p35 L=5 mult=1
XR78 net77 net76 AVSS sky130_fd_pr__res_high_po_0p35 L=5 mult=1
XR79 net78 net77 AVSS sky130_fd_pr__res_high_po_0p35 L=5 mult=1
XR80 net79 net78 AVSS sky130_fd_pr__res_high_po_0p35 L=5 mult=1
XR81 net80 net79 AVSS sky130_fd_pr__res_high_po_0p35 L=5 mult=1
XR82 net81 net80 AVSS sky130_fd_pr__res_high_po_0p35 L=5 mult=1
XR83 net82 net81 AVSS sky130_fd_pr__res_high_po_0p35 L=5 mult=1
XR84 net83 net82 AVSS sky130_fd_pr__res_high_po_0p35 L=5 mult=1
XR85 net84 net83 AVSS sky130_fd_pr__res_high_po_0p35 L=5 mult=1
XR86 net85 net84 AVSS sky130_fd_pr__res_high_po_0p35 L=5 mult=1
XR87 net86 net85 AVSS sky130_fd_pr__res_high_po_0p35 L=5 mult=1
XR88 net87 net86 AVSS sky130_fd_pr__res_high_po_0p35 L=5 mult=1
XR89 net88 net87 AVSS sky130_fd_pr__res_high_po_0p35 L=5 mult=1
XR90 net89 net88 AVSS sky130_fd_pr__res_high_po_0p35 L=5 mult=1
XR91 net90 net89 AVSS sky130_fd_pr__res_high_po_0p35 L=5 mult=1
XR92 net91 net90 AVSS sky130_fd_pr__res_high_po_0p35 L=5 mult=1
XR93 net92 net91 AVSS sky130_fd_pr__res_high_po_0p35 L=5 mult=1
XR94 net93 net92 AVSS sky130_fd_pr__res_high_po_0p35 L=5 mult=1
XR95 net94 net93 AVSS sky130_fd_pr__res_high_po_0p35 L=5 mult=1
XR96 net95 net94 AVSS sky130_fd_pr__res_high_po_0p35 L=5 mult=1
XR97 net96 net95 AVSS sky130_fd_pr__res_high_po_0p35 L=5 mult=1
XR98 net97 net96 AVSS sky130_fd_pr__res_high_po_0p35 L=5 mult=1
XR99 net98 net97 AVSS sky130_fd_pr__res_high_po_0p35 L=5 mult=1
XR100 net99 net98 AVSS sky130_fd_pr__res_high_po_0p35 L=5 mult=1
XR101 net100 net99 AVSS sky130_fd_pr__res_high_po_0p35 L=5 mult=1
XR102 net101 net100 AVSS sky130_fd_pr__res_high_po_0p35 L=5 mult=1
XR103 net102 net101 AVSS sky130_fd_pr__res_high_po_0p35 L=5 mult=1
XR104 net103 net102 AVSS sky130_fd_pr__res_high_po_0p35 L=5 mult=1
XR105 net104 net103 AVSS sky130_fd_pr__res_high_po_0p35 L=5 mult=1
XR106 net105 net104 AVSS sky130_fd_pr__res_high_po_0p35 L=5 mult=1
XR107 net106 net105 AVSS sky130_fd_pr__res_high_po_0p35 L=5 mult=1
XR108 net107 net106 AVSS sky130_fd_pr__res_high_po_0p35 L=5 mult=1
XR109 net108 net107 AVSS sky130_fd_pr__res_high_po_0p35 L=5 mult=1
XR110 net109 net108 AVSS sky130_fd_pr__res_high_po_0p35 L=5 mult=1
XR111 net110 net109 AVSS sky130_fd_pr__res_high_po_0p35 L=5 mult=1
XR112 net111 net110 AVSS sky130_fd_pr__res_high_po_0p35 L=5 mult=1
XR113 net112 net111 AVSS sky130_fd_pr__res_high_po_0p35 L=5 mult=1
XR114 net113 net112 AVSS sky130_fd_pr__res_high_po_0p35 L=5 mult=1
XR115 net114 net113 AVSS sky130_fd_pr__res_high_po_0p35 L=5 mult=1
XR116 net115 net114 AVSS sky130_fd_pr__res_high_po_0p35 L=5 mult=1
XR117 net116 net115 AVSS sky130_fd_pr__res_high_po_0p35 L=5 mult=1
XR118 net117 net116 AVSS sky130_fd_pr__res_high_po_0p35 L=5 mult=1
XR119 net118 net117 AVSS sky130_fd_pr__res_high_po_0p35 L=5 mult=1
XR120 net119 net118 AVSS sky130_fd_pr__res_high_po_0p35 L=5 mult=1
XR121 net120 net119 AVSS sky130_fd_pr__res_high_po_0p35 L=5 mult=1
XR122 net121 net120 AVSS sky130_fd_pr__res_high_po_0p35 L=5 mult=1
XR123 net122 net121 AVSS sky130_fd_pr__res_high_po_0p35 L=5 mult=1
XR124 net123 net122 AVSS sky130_fd_pr__res_high_po_0p35 L=5 mult=1
XR125 net124 net123 AVSS sky130_fd_pr__res_high_po_0p35 L=5 mult=1
XR126 net125 net124 AVSS sky130_fd_pr__res_high_po_0p35 L=5 mult=1
XR127 VE_VREF net125 AVSS sky130_fd_pr__res_high_po_0p35 L=5 mult=1
XR128 AVSS AVSS AVSS sky130_fd_pr__res_high_po_0p35 L=5 mult=83 m=83
**.ends
.end
