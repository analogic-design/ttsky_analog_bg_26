* SPICE3 file created from sky130_fd_pr__pfet_01v8_lvt_KLHPYA.ext - technology: sky130A

.subckt sky130_fd_pr__pfet_01v8_lvt_KLHPYA B D S G
X0 S G D B sky130_fd_pr__pfet_01v8_lvt ad=2.32 pd=16.58 as=2.32 ps=16.58 w=8 l=6
C0 G B 2.22617f
C1 B VSUBS 10.9663f
.ends
