** sch_path: /home/lenny/projects/test/layout/bg2_opamp_tb.sch
**.subckt bg2_opamp_tb
V1 VDDA 0 1.8
V2 V_PLUS 0 0
V3 V_MINUS 0 0.7
V4 net1 0 0
x1 VDDA V_OUT V_PLUS V_MINUS net1 bg2_opamp
**** begin user architecture code

.param strict_subcts=0
.include bg2_opamp.spice
.lib /usr/local/share/pdk/sky130A/libs.tech/ngspice/sky130.lib.spice tt
.control
dc V2 0.5 0.9 0.05
print all
save all
write bg2_opamp_data.raw
.endc

**** end user architecture code
**.ends
.end
