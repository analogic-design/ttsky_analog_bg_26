** sch_path: /home/lenny/projects/test/layout/bg2_bjt_array_tb.sch
**.subckt bg2_bjt_array_tb
V1 V_PLUS 0 1
x1 V_PLUS VE_MINUS VE_VREF 0 bg2_bjt_array
V2 VE_MINUS 0 1
V3 VE_VREF 0 1
**** begin user architecture code

.param strict_subcts=0
.include bg2_bjt_array.spice
.lib /usr/local/share/pdk/sky130A/libs.tech/ngspice/sky130.lib.spice tt
.control
dc V1 0 1.8 0.2
print all
save all
write bg2_bjt_array_data.raw
.endc

**** end user architecture code
**.ends
.end
