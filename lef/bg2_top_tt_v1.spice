** sch_path: /home/lenny/projects/test/layout/bg2_top_tt_v1.sch
**.subckt bg2_top_tt_v1 VGND VPWR
*.ipin VGND
*.ipin VPWR
x3 VPWR VGND bg2_moscap
**.ends

* expanding   symbol:  bg2_moscap.sym # of pins=2
** sym_path: /home/lenny/projects/test/layout/bg2_moscap.sym
** sch_path: /home/lenny/projects/test/layout/bg2_moscap.sch
.subckt bg2_moscap VDDA AVSS
*.ipin VDDA
*.ipin AVSS
XM1 AVSS VDDA AVSS AVSS sky130_fd_pr__nfet_01v8 L=10 W=10 nf=1 ad=2.9 as=2.9 pd=20.58 ps=20.58 nrd=0.029 nrs=0.029 sa=0 sb=0 sd=0
+ mult=1
XM2 AVSS VDDA AVSS AVSS sky130_fd_pr__nfet_01v8 L=10 W=10 nf=1 ad=2.9 as=2.9 pd=20.58 ps=20.58 nrd=0.029 nrs=0.029 sa=0 sb=0 sd=0
+ mult=1
XM3 AVSS VDDA AVSS AVSS sky130_fd_pr__nfet_01v8 L=10 W=10 nf=1 ad=2.9 as=2.9 pd=20.58 ps=20.58 nrd=0.029 nrs=0.029 sa=0 sb=0 sd=0
+ mult=1
XM4 AVSS VDDA AVSS AVSS sky130_fd_pr__nfet_01v8 L=10 W=10 nf=1 ad=2.9 as=2.9 pd=20.58 ps=20.58 nrd=0.029 nrs=0.029 sa=0 sb=0 sd=0
+ mult=1
XM5 AVSS VDDA AVSS AVSS sky130_fd_pr__nfet_01v8 L=10 W=10 nf=1 ad=2.9 as=2.9 pd=20.58 ps=20.58 nrd=0.029 nrs=0.029 sa=0 sb=0 sd=0
+ mult=1
XM6 AVSS VDDA AVSS AVSS sky130_fd_pr__nfet_01v8 L=10 W=10 nf=1 ad=2.9 as=2.9 pd=20.58 ps=20.58 nrd=0.029 nrs=0.029 sa=0 sb=0 sd=0
+ mult=1
XM7 AVSS VDDA AVSS AVSS sky130_fd_pr__nfet_01v8 L=10 W=10 nf=1 ad=2.9 as=2.9 pd=20.58 ps=20.58 nrd=0.029 nrs=0.029 sa=0 sb=0 sd=0
+ mult=1
XM8 AVSS VDDA AVSS AVSS sky130_fd_pr__nfet_01v8 L=10 W=10 nf=1 ad=2.9 as=2.9 pd=20.58 ps=20.58 nrd=0.029 nrs=0.029 sa=0 sb=0 sd=0
+ mult=1
XM9 AVSS VDDA AVSS AVSS sky130_fd_pr__nfet_01v8 L=10 W=10 nf=1 ad=2.9 as=2.9 pd=20.58 ps=20.58 nrd=0.029 nrs=0.029 sa=0 sb=0 sd=0
+ mult=1
XM10 AVSS VDDA AVSS AVSS sky130_fd_pr__nfet_01v8 L=10 W=10 nf=1 ad=2.9 as=2.9 pd=20.58 ps=20.58 nrd=0.029 nrs=0.029 sa=0 sb=0 sd=0
+ mult=1
.ends

.end
