* SPICE3 file created from bg2_startup.ext - technology: sky130A

.subckt sky130_fd_pr__pfet_01v8_lvt_E9YYQQ B D S G VSUBS
X0 S G D B sky130_fd_pr__pfet_01v8_lvt ad=1.16 pd=8.58 as=1.16 ps=8.58 w=4 l=6
C0 B VSUBS 5.61681f
.ends

.subckt sky130_fd_pr__nfet_01v8_BH8H9B B D S G
X0 S G D B sky130_fd_pr__nfet_01v8 ad=0.29 pd=2.58 as=0.29 ps=2.58 w=1 l=100
C0 S B 15.37243f
C1 D B 15.37243f
.ends

.subckt sky130_fd_pr__pfet_01v8_lvt_ATKBUG B D S G VSUBS
X0 S G D B sky130_fd_pr__pfet_01v8_lvt ad=1.16 pd=8.58 as=1.16 ps=8.58 w=4 l=6
C0 B VSUBS 5.61681f
.ends

.subckt sky130_fd_pr__pfet_01v8_lvt_RVE6BE B D S G VSUBS
X0 S G D B sky130_fd_pr__pfet_01v8_lvt ad=1.16 pd=8.58 as=1.16 ps=8.58 w=4 l=3
C0 B VSUBS 4.07429f
.ends

.subckt bg2_startup VDDA vbp1 V_PLUS VSSA
Xsky130_fd_pr__pfet_01v8_lvt_E9YYQQ_0 VDDA VDDA sky130_fd_pr__nfet_01v8_BH8H9B_0/G
+ vbp1 VSSA sky130_fd_pr__pfet_01v8_lvt_E9YYQQ
Xsky130_fd_pr__nfet_01v8_BH8H9B_0 VSSA sky130_fd_pr__nfet_01v8_BH8H9B_0/G VSSA sky130_fd_pr__nfet_01v8_BH8H9B_0/G
+ sky130_fd_pr__nfet_01v8_BH8H9B
Xsky130_fd_pr__pfet_01v8_lvt_ATKBUG_0 VDDA sky130_fd_pr__nfet_01v8_BH8H9B_0/G VDDA
+ vbp1 VSSA sky130_fd_pr__pfet_01v8_lvt_ATKBUG
Xsky130_fd_pr__pfet_01v8_lvt_RVE6BE_0 VDDA vbp1 V_PLUS sky130_fd_pr__nfet_01v8_BH8H9B_0/G
+ VSSA sky130_fd_pr__pfet_01v8_lvt_RVE6BE
.ends
