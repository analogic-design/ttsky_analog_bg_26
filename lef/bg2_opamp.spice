** sch_path: /home/lenny/projects/test/layout/bg2_opamp.sch
**.subckt bg2_opamp VDDA V_OUT V_PLUS V_MINUS VSSA
*.ipin VDDA
*.ipin VSSA
*.ipin V_PLUS
*.ipin V_MINUS
*.opin V_OUT
XM3 V_OUT V_PLUS vs VSSA sky130_fd_pr__nfet_01v8 L=6 W=4 nf=1 ad=1.16 as=1.16 pd=8.58 ps=8.58 nrd=0.0725 nrs=0.0725 sa=0 sb=0 sd=0
+ mult=1
XM7 V_OUT vb VDDA VDDA sky130_fd_pr__pfet_01v8_lvt L=6 W=4 nf=1 ad=1.16 as=1.16 pd=8.58 ps=8.58 nrd=0.0725 nrs=0.0725 sa=0 sb=0
+ sd=0 mult=1
XM8 vb vb VDDA VDDA sky130_fd_pr__pfet_01v8_lvt L=6 W=4 nf=1 ad=1.16 as=1.16 pd=8.58 ps=8.58 nrd=0.0725 nrs=0.0725 sa=0 sb=0 sd=0
+ mult=1
XM9 vb V_MINUS vs VSSA sky130_fd_pr__nfet_01v8 L=6 W=4 nf=1 ad=1.16 as=1.16 pd=8.58 ps=8.58 nrd=0.0725 nrs=0.0725 sa=0 sb=0 sd=0
+ mult=1
XM10 vs vb VSSA VSSA sky130_fd_pr__nfet_01v8 L=10 W=0.5 nf=1 ad=0.145 as=0.145 pd=1.58 ps=1.58 nrd=0.58 nrs=0.58 sa=0 sb=0 sd=0
+ mult=1
XM1 V_OUT vb VDDA VDDA sky130_fd_pr__pfet_01v8_lvt L=6 W=4 nf=1 ad=1.16 as=1.16 pd=8.58 ps=8.58 nrd=0.0725 nrs=0.0725 sa=0 sb=0
+ sd=0 mult=1
XM2 vb vb VDDA VDDA sky130_fd_pr__pfet_01v8_lvt L=6 W=4 nf=1 ad=1.16 as=1.16 pd=8.58 ps=8.58 nrd=0.0725 nrs=0.0725 sa=0 sb=0 sd=0
+ mult=1
XM6 V_OUT V_PLUS vs VSSA sky130_fd_pr__nfet_01v8 L=6 W=4 nf=1 ad=1.16 as=1.16 pd=8.58 ps=8.58 nrd=0.0725 nrs=0.0725 sa=0 sb=0 sd=0
+ mult=1
XM4 vb V_MINUS vs VSSA sky130_fd_pr__nfet_01v8 L=6 W=4 nf=1 ad=1.16 as=1.16 pd=8.58 ps=8.58 nrd=0.0725 nrs=0.0725 sa=0 sb=0 sd=0
+ mult=1
XM5 vs vb VSSA VSSA sky130_fd_pr__nfet_01v8 L=10 W=0.5 nf=1 ad=0.145 as=0.145 pd=1.58 ps=1.58 nrd=0.58 nrs=0.58 sa=0 sb=0 sd=0
+ mult=1
**.ends
.end
