** sch_path: /home/lenny/projects/test/layout/bg2_currentmirror_xschem.sch
**.subckt bg2_currentmirror_xschem VDDA vbp1 V_PLUS V_MINUS V_REF
*.ipin VDDA
*.ipin vbp1
*.opin V_PLUS
*.opin V_MINUS
*.opin V_REF
XM9 VDDA VDDA VDDA VDDA sky130_fd_pr__pfet_01v8_lvt L=6 W=4 nf=1 ad=1.16 as=1.16 pd=8.58 ps=8.58 nrd=0.0725 nrs=0.0725 sa=0 sb=0
+ sd=0 mult=1
XM3 V_PLUS vbp1 VDDA VDDA sky130_fd_pr__pfet_01v8_lvt L=6 W=4 nf=1 ad=1.16 as=1.16 pd=8.58 ps=8.58 nrd=0.0725 nrs=0.0725 sa=0 sb=0
+ sd=0 mult=1
XM1 VDDA VDDA VDDA VDDA sky130_fd_pr__pfet_01v8_lvt L=6 W=4 nf=1 ad=1.16 as=1.16 pd=8.58 ps=8.58 nrd=0.0725 nrs=0.0725 sa=0 sb=0
+ sd=0 mult=1
XM2 VDDA VDDA VDDA VDDA sky130_fd_pr__pfet_01v8_lvt L=6 W=4 nf=1 ad=1.16 as=1.16 pd=8.58 ps=8.58 nrd=0.0725 nrs=0.0725 sa=0 sb=0
+ sd=0 mult=1
XM10 VDDA VDDA VDDA VDDA sky130_fd_pr__pfet_01v8_lvt L=6 W=4 nf=1 ad=1.16 as=1.16 pd=8.58 ps=8.58 nrd=0.0725 nrs=0.0725 sa=0 sb=0
+ sd=0 mult=1
XM4 V_PLUS vbp1 VDDA VDDA sky130_fd_pr__pfet_01v8_lvt L=6 W=4 nf=1 ad=1.16 as=1.16 pd=8.58 ps=8.58 nrd=0.0725 nrs=0.0725 sa=0 sb=0
+ sd=0 mult=1
XM5 V_MINUS vbp1 VDDA VDDA sky130_fd_pr__pfet_01v8_lvt L=6 W=4 nf=1 ad=1.16 as=1.16 pd=8.58 ps=8.58 nrd=0.0725 nrs=0.0725 sa=0
+ sb=0 sd=0 mult=1
XM6 V_MINUS vbp1 VDDA VDDA sky130_fd_pr__pfet_01v8_lvt L=6 W=4 nf=1 ad=1.16 as=1.16 pd=8.58 ps=8.58 nrd=0.0725 nrs=0.0725 sa=0
+ sb=0 sd=0 mult=1
XM7 V_REF vbp1 VDDA VDDA sky130_fd_pr__pfet_01v8_lvt L=6 W=4 nf=1 ad=1.16 as=1.16 pd=8.58 ps=8.58 nrd=0.0725 nrs=0.0725 sa=0 sb=0
+ sd=0 mult=1
XM8 V_REF vbp1 VDDA VDDA sky130_fd_pr__pfet_01v8_lvt L=6 W=4 nf=1 ad=1.16 as=1.16 pd=8.58 ps=8.58 nrd=0.0725 nrs=0.0725 sa=0 sb=0
+ sd=0 mult=1
**.ends
.end
