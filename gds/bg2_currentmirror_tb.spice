** sch_path: /home/lenny/projects/test/layout/bg2_currentmirror_tb.sch
**.subckt bg2_currentmirror_tb
V1 net1 0 1.8
V2 net2 0 1.2
x1 net1 net2 net4 net5 net3 bg2_currentmirror
V3 net3 0 0
V4 net4 0 0
V5 net5 0 0
**** begin user architecture code

.param strict_subcts=0
.include bg2_currentmirror.spice
.lib /usr/local/share/pdk/sky130A/libs.tech/ngspice/sky130.lib.spice tt
.control
dc V1 0 1.8 0.2
print all
save all
write bg2_currentmirror_data.raw
.endc

**** end user architecture code
**.ends
.end
