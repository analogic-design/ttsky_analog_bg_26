** sch_path: /home/lenny/projects/test/layout/bg2_startup_tb.sch
**.subckt bg2_startup_tb
V1 VDDA 0 1.8
V4 net1 0 0
x1 VDDA vbp1 V_PLUS net1 bg2_startup
V2 vbp1 0 1.2
V3 V_PLUS 0 0.7
**** begin user architecture code

.param strict_subcts=0
.include bg2_startup.spice
.lib /usr/local/share/pdk/sky130A/libs.tech/ngspice/sky130.lib.spice tt
.control
tran 1m 10m
print all
save all
write bg2_startup_data.raw
.endc

**** end user architecture code
**.ends
.end
