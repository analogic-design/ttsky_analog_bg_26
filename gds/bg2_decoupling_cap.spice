* SPICE3 file created from bg2_decoupling_cap.ext - technology: sky130A

.subckt sky130_fd_pr__pfet_01v8_lvt_VVFQL6 B D0 S0 G0 D1 S1 G1 D2 S2 G2 D3 S3 G3 D4
+ S4 G4 D5 S5 G5 D6 S6 G6 D7 S7 G7 D8 S8 G8 D9 S9 G9 VSUBS
X0 S3 G3 D3 B sky130_fd_pr__pfet_01v8_lvt ad=2.9 pd=20.58 as=2.9 ps=20.58 w=10 l=10
X1 S5 G5 D5 B sky130_fd_pr__pfet_01v8_lvt ad=2.9 pd=20.58 as=2.9 ps=20.58 w=10 l=10
X2 S9 G9 D9 B sky130_fd_pr__pfet_01v8_lvt ad=2.9 pd=20.58 as=2.9 ps=20.58 w=10 l=10
X3 S4 G4 D4 B sky130_fd_pr__pfet_01v8_lvt ad=2.9 pd=20.58 as=2.9 ps=20.58 w=10 l=10
X4 S2 G2 D2 B sky130_fd_pr__pfet_01v8_lvt ad=2.9 pd=20.58 as=2.9 ps=20.58 w=10 l=10
X5 S7 G7 D7 B sky130_fd_pr__pfet_01v8_lvt ad=2.9 pd=20.58 as=2.9 ps=20.58 w=10 l=10
X6 S0 G0 D0 B sky130_fd_pr__pfet_01v8_lvt ad=2.9 pd=20.58 as=2.9 ps=20.58 w=10 l=10
X7 S1 G1 D1 B sky130_fd_pr__pfet_01v8_lvt ad=2.9 pd=20.58 as=2.9 ps=20.58 w=10 l=10
X8 S6 G6 D6 B sky130_fd_pr__pfet_01v8_lvt ad=2.9 pd=20.58 as=2.9 ps=20.58 w=10 l=10
X9 S8 G8 D8 B sky130_fd_pr__pfet_01v8_lvt ad=2.9 pd=20.58 as=2.9 ps=20.58 w=10 l=10
C0 G9 B 2.09021f
C1 G0 B 2.291f
C2 B VSUBS 0.16463p
.ends

.subckt bg2_decoupling_cap VDDA vbp1
Xsky130_fd_pr__pfet_01v8_lvt_VVFQL6_0 VDDA VDDA VDDA vbp1 VDDA VDDA vbp1 VDDA VDDA
+ vbp1 VDDA VDDA vbp1 VDDA VDDA vbp1 VDDA VDDA vbp1 VDDA VDDA vbp1 VDDA VDDA vbp1
+ VDDA VDDA vbp1 VDDA VDDA vbp1 VSUBS sky130_fd_pr__pfet_01v8_lvt_VVFQL6
C0 vbp1 VDDA 2.71291f
.ends
