* SPICE3 file created from bg2_top_tt_v5_lvs.ext - technology: sky130A

X0 bg2_opamp_0/vb bg2_opamp_0/vb VPWR VPWR sky130_fd_pr__pfet_01v8_lvt ad=1.16 pd=8.58 as=1.16 ps=8.58 w=4 l=6
X1 VPWR bg2_opamp_0/vb vbp1 VPWR sky130_fd_pr__pfet_01v8_lvt ad=73.08005 pd=523.15002 as=2.32002 ps=17.165 w=4 l=6
X2 vbp1 bg2_opamp_0/vb VPWR VPWR sky130_fd_pr__pfet_01v8_lvt ad=1.16 pd=8.58 as=1.16 ps=8.58 w=4 l=6
X3 bg2_opamp_0/vb V_MINUS bg2_opamp_0/vs VGND sky130_fd_pr__nfet_01v8 ad=1.16 pd=8.58 as=1.16 ps=8.58 w=4 l=6
X4 bg2_opamp_0/vs V_MINUS bg2_opamp_0/vb VGND sky130_fd_pr__nfet_01v8 ad=1.16 pd=8.58 as=1.16 ps=8.58 w=4 l=6
X5 VPWR bg2_opamp_0/vb bg2_opamp_0/vb VPWR sky130_fd_pr__pfet_01v8_lvt ad=1.16 pd=8.58 as=1.16 ps=8.58 w=4 l=6
X6 vbp1 V_PLUS bg2_opamp_0/vs VGND sky130_fd_pr__nfet_01v8 ad=1.16 pd=8.58 as=1.16 ps=8.58 w=4 l=6
X7 bg2_opamp_0/vs V_PLUS vbp1 VGND sky130_fd_pr__nfet_01v8 ad=1.16 pd=8.58 as=1.16 ps=8.58 w=4 l=6
X8 VGND bg2_opamp_0/vb bg2_opamp_0/vs VGND sky130_fd_pr__nfet_01v8 ad=0.145 pd=1.58 as=0.145 ps=1.58 w=0.5 l=10
X9 bg2_opamp_0/vs bg2_opamp_0/vb VGND VGND sky130_fd_pr__nfet_01v8 ad=0.145 pd=1.58 as=0.145 ps=1.58 w=0.5 l=10
X10 VGND VPWR VGND VGND sky130_fd_pr__nfet_01v8 ad=2.9 pd=20.58 as=2.9 ps=20.58 w=10 l=10
X11 VGND VPWR VGND VGND sky130_fd_pr__nfet_01v8 ad=2.9 pd=20.58 as=2.9 ps=20.58 w=10 l=10
X12 VGND VPWR VGND VGND sky130_fd_pr__nfet_01v8 ad=2.9 pd=20.58 as=2.9 ps=20.58 w=10 l=10
X13 VGND VPWR VGND VGND sky130_fd_pr__nfet_01v8 ad=2.9 pd=20.58 as=2.9 ps=20.58 w=10 l=10
X14 VGND VPWR VGND VGND sky130_fd_pr__nfet_01v8 ad=2.9 pd=20.58 as=2.9 ps=20.58 w=10 l=10
X15 VGND VPWR VGND VGND sky130_fd_pr__nfet_01v8 ad=2.9 pd=20.58 as=2.9 ps=20.58 w=10 l=10
X16 VGND VPWR VGND VGND sky130_fd_pr__nfet_01v8 ad=2.9 pd=20.58 as=2.9 ps=20.58 w=10 l=10
X17 VGND VPWR VGND VGND sky130_fd_pr__nfet_01v8 ad=2.9 pd=20.58 as=2.9 ps=20.58 w=10 l=10
X18 VGND VPWR VGND VGND sky130_fd_pr__nfet_01v8 ad=2.9 pd=20.58 as=2.9 ps=20.58 w=10 l=10
X19 VGND VPWR VGND VGND sky130_fd_pr__nfet_01v8 ad=2.9 pd=20.58 as=2.9 ps=20.58 w=10 l=10
X20 VPWR VPWR VPWR VPWR sky130_fd_pr__pfet_01v8_lvt ad=1.16 pd=8.58 as=1.16 ps=8.58 w=4 l=6
X21 V_PLUS vbp1 VPWR VPWR sky130_fd_pr__pfet_01v8_lvt ad=2.32002 pd=17.165 as=0 ps=0 w=4 l=6
X22 VPWR vbp1 V_PLUS VPWR sky130_fd_pr__pfet_01v8_lvt ad=0 pd=0 as=0 ps=0 w=4 l=6
X23 V_MINUS vbp1 VPWR VPWR sky130_fd_pr__pfet_01v8_lvt ad=1.16003 pd=8.585 as=0 ps=0 w=4 l=6
X24 V_REF vbp1 VPWR VPWR sky130_fd_pr__pfet_01v8_lvt ad=1.16003 pd=8.585 as=0 ps=0 w=4 l=6
X25 VPWR vbp1 V_MINUS VPWR sky130_fd_pr__pfet_01v8_lvt ad=0 pd=0 as=0 ps=0 w=4 l=6
X26 VPWR vbp1 V_REF VPWR sky130_fd_pr__pfet_01v8_lvt ad=0 pd=0 as=0 ps=0 w=4 l=6
X27 VPWR VPWR VPWR VPWR sky130_fd_pr__pfet_01v8_lvt ad=0 pd=0 as=0 ps=0 w=4 l=6
X28 VPWR VPWR VPWR VPWR sky130_fd_pr__pfet_01v8_lvt ad=1.16 pd=8.58 as=1.16 ps=8.58 w=4 l=6
X29 VPWR VPWR VPWR VPWR sky130_fd_pr__pfet_01v8_lvt ad=1.16 pd=8.58 as=1.16 ps=8.58 w=4 l=6
X30 VPWR vbp1 VPWR VPWR sky130_fd_pr__pfet_01v8_lvt ad=2.9 pd=20.58 as=2.9 ps=20.58 w=10 l=10
X31 VPWR vbp1 VPWR VPWR sky130_fd_pr__pfet_01v8_lvt ad=2.9 pd=20.58 as=2.9 ps=20.58 w=10 l=10
X32 VPWR vbp1 VPWR VPWR sky130_fd_pr__pfet_01v8_lvt ad=2.9 pd=20.58 as=2.9 ps=20.58 w=10 l=10
X33 VPWR vbp1 VPWR VPWR sky130_fd_pr__pfet_01v8_lvt ad=2.9 pd=20.58 as=2.9 ps=20.58 w=10 l=10
X34 VPWR vbp1 VPWR VPWR sky130_fd_pr__pfet_01v8_lvt ad=2.9 pd=20.58 as=2.9 ps=20.58 w=10 l=10
X35 VPWR vbp1 VPWR VPWR sky130_fd_pr__pfet_01v8_lvt ad=2.9 pd=20.58 as=2.9 ps=20.58 w=10 l=10
X36 VPWR vbp1 VPWR VPWR sky130_fd_pr__pfet_01v8_lvt ad=2.9 pd=20.58 as=2.9 ps=20.58 w=10 l=10
X37 VPWR vbp1 VPWR VPWR sky130_fd_pr__pfet_01v8_lvt ad=2.9 pd=20.58 as=2.9 ps=20.58 w=10 l=10
X38 VPWR vbp1 VPWR VPWR sky130_fd_pr__pfet_01v8_lvt ad=2.9 pd=20.58 as=2.9 ps=20.58 w=10 l=10
X39 VPWR vbp1 VPWR VPWR sky130_fd_pr__pfet_01v8_lvt ad=2.9 pd=20.58 as=2.9 ps=20.58 w=10 l=10
X40 bg2_startup_0/sky130_fd_pr__nfet_01v8_BH8H9B_0/G vbp1 VPWR VPWR sky130_fd_pr__pfet_01v8_lvt ad=1.16 pd=8.58 as=1.16 ps=8.58 w=4 l=6
X41 VGND bg2_startup_0/sky130_fd_pr__nfet_01v8_BH8H9B_0/G bg2_startup_0/sky130_fd_pr__nfet_01v8_BH8H9B_0/G VGND sky130_fd_pr__nfet_01v8 ad=0.29 pd=2.58 as=0.29 ps=2.58 w=1 l=100
X42 VPWR vbp1 bg2_startup_0/sky130_fd_pr__nfet_01v8_BH8H9B_0/G VPWR sky130_fd_pr__pfet_01v8_lvt ad=0 pd=0 as=1.16003 ps=8.585 w=4 l=6
X43 V_PLUS bg2_startup_0/sky130_fd_pr__nfet_01v8_BH8H9B_0/G vbp1 VPWR sky130_fd_pr__pfet_01v8_lvt ad=1.16 pd=8.58 as=1.16 ps=8.58 w=4 l=3
