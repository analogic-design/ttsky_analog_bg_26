* SPICE3 file created from bg2_moscap.ext - technology: sky130A

.subckt sky130_fd_pr__nfet_01v8_7BGF84 B D0 S0 G0 D1 S1 G1 D2 S2 G2 D3 S3 G3 D4 S4
+ G4 D5 S5 G5 D6 S6 G6 D7 S7 G7 D8 S8 G8 D9 S9 G9
X0 S8 G8 D8 B sky130_fd_pr__nfet_01v8 ad=2.9 pd=20.58 as=2.9 ps=20.58 w=10 l=10
X1 S4 G4 D4 B sky130_fd_pr__nfet_01v8 ad=2.9 pd=20.58 as=2.9 ps=20.58 w=10 l=10
X2 S5 G5 D5 B sky130_fd_pr__nfet_01v8 ad=2.9 pd=20.58 as=2.9 ps=20.58 w=10 l=10
X3 S0 G0 D0 B sky130_fd_pr__nfet_01v8 ad=2.9 pd=20.58 as=2.9 ps=20.58 w=10 l=10
X4 S9 G9 D9 B sky130_fd_pr__nfet_01v8 ad=2.9 pd=20.58 as=2.9 ps=20.58 w=10 l=10
X5 S3 G3 D3 B sky130_fd_pr__nfet_01v8 ad=2.9 pd=20.58 as=2.9 ps=20.58 w=10 l=10
X6 S6 G6 D6 B sky130_fd_pr__nfet_01v8 ad=2.9 pd=20.58 as=2.9 ps=20.58 w=10 l=10
X7 S2 G2 D2 B sky130_fd_pr__nfet_01v8 ad=2.9 pd=20.58 as=2.9 ps=20.58 w=10 l=10
X8 S7 G7 D7 B sky130_fd_pr__nfet_01v8 ad=2.9 pd=20.58 as=2.9 ps=20.58 w=10 l=10
X9 S1 G1 D1 B sky130_fd_pr__nfet_01v8 ad=2.9 pd=20.58 as=2.9 ps=20.58 w=10 l=10
.ends

.subckt bg2_moscap VDDA AVSS
Xsky130_fd_pr__nfet_01v8_7BGF84_0 AVSS AVSS AVSS VDDA AVSS AVSS VDDA AVSS AVSS VDDA
+ AVSS AVSS VDDA AVSS AVSS VDDA AVSS AVSS VDDA AVSS AVSS VDDA AVSS AVSS VDDA AVSS
+ AVSS VDDA AVSS AVSS VDDA sky130_fd_pr__nfet_01v8_7BGF84
C0 VDDA AVSS 3.52618f
.ends
